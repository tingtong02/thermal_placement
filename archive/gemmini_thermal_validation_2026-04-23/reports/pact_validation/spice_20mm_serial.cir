.title spice solver
Vg GND 0 318.15
I_0_0_0 GND Node0_0_0 0.48717948717948717A
R_0_0_0_1 Node0_0_0 Node0_0_1 77.0
R_0_0_0_2 Node0_0_0 Node0_1_0 77.0
R_0_0_0_3 Node0_0_0 Node1_0_0 0.7700000000000001
I_0_0_1 GND Node0_0_1 0.48717948717948717A
R_0_0_1_1 Node0_0_1 Node0_0_2 77.0
R_0_0_1_2 Node0_0_1 Node0_1_1 77.0
R_0_0_1_3 Node0_0_1 Node1_0_1 0.7700000000000001
I_0_0_2 GND Node0_0_2 0.48717948717948717A
R_0_0_2_1 Node0_0_2 Node0_0_3 77.0
R_0_0_2_2 Node0_0_2 Node0_1_2 77.0
R_0_0_2_3 Node0_0_2 Node1_0_2 0.7700000000000001
I_0_0_3 GND Node0_0_3 0.48717948717948717A
R_0_0_3_1 Node0_0_3 Node0_0_4 77.0
R_0_0_3_2 Node0_0_3 Node0_1_3 77.0
R_0_0_3_3 Node0_0_3 Node1_0_3 0.7700000000000001
I_0_0_4 GND Node0_0_4 0.48717948717948717A
R_0_0_4_1 Node0_0_4 Node0_0_5 77.0
R_0_0_4_2 Node0_0_4 Node0_1_4 77.0
R_0_0_4_3 Node0_0_4 Node1_0_4 0.7700000000000001
I_0_0_5 GND Node0_0_5 0.48717948717948717A
R_0_0_5_1 Node0_0_5 Node0_0_6 77.0
R_0_0_5_2 Node0_0_5 Node0_1_5 77.0
R_0_0_5_3 Node0_0_5 Node1_0_5 0.7700000000000001
I_0_0_6 GND Node0_0_6 0.48717948717948717A
R_0_0_6_1 Node0_0_6 Node0_0_7 77.0
R_0_0_6_2 Node0_0_6 Node0_1_6 77.0
R_0_0_6_3 Node0_0_6 Node1_0_6 0.7700000000000001
I_0_0_7 GND Node0_0_7 0.48717948717948717A
R_0_0_7_1 Node0_0_7 Node0_0_8 77.0
R_0_0_7_2 Node0_0_7 Node0_1_7 77.0
R_0_0_7_3 Node0_0_7 Node1_0_7 0.7700000000000001
I_0_0_8 GND Node0_0_8 0.48717948717948717A
R_0_0_8_1 Node0_0_8 Node0_0_9 77.0
R_0_0_8_2 Node0_0_8 Node0_1_8 77.0
R_0_0_8_3 Node0_0_8 Node1_0_8 0.7700000000000001
I_0_0_9 GND Node0_0_9 0.48717948717948717A
R_0_0_9_1 Node0_0_9 Node0_0_10 77.0
R_0_0_9_2 Node0_0_9 Node0_1_9 77.0
R_0_0_9_3 Node0_0_9 Node1_0_9 0.7700000000000001
I_0_0_10 GND Node0_0_10 0.48717948717948717A
R_0_0_10_1 Node0_0_10 Node0_0_11 77.0
R_0_0_10_2 Node0_0_10 Node0_1_10 77.0
R_0_0_10_3 Node0_0_10 Node1_0_10 0.7700000000000001
I_0_0_11 GND Node0_0_11 0.48717948717948717A
R_0_0_11_1 Node0_0_11 Node0_0_12 77.0
R_0_0_11_2 Node0_0_11 Node0_1_11 77.0
R_0_0_11_3 Node0_0_11 Node1_0_11 0.7700000000000001
I_0_0_12 GND Node0_0_12 0.48717948717948717A
R_0_0_12_1 Node0_0_12 Node0_0_13 77.0
R_0_0_12_2 Node0_0_12 Node0_1_12 77.0
R_0_0_12_3 Node0_0_12 Node1_0_12 0.7700000000000001
I_0_0_13 GND Node0_0_13 0.48717948717948717A
R_0_0_13_1 Node0_0_13 Node0_0_14 77.0
R_0_0_13_2 Node0_0_13 Node0_1_13 77.0
R_0_0_13_3 Node0_0_13 Node1_0_13 0.7700000000000001
I_0_0_14 GND Node0_0_14 0.48717948717948717A
R_0_0_14_1 Node0_0_14 Node0_0_15 77.0
R_0_0_14_2 Node0_0_14 Node0_1_14 77.0
R_0_0_14_3 Node0_0_14 Node1_0_14 0.7700000000000001
I_0_0_15 GND Node0_0_15 0.48717948717948717A
R_0_0_15_1 Node0_0_15 Node0_0_16 77.0
R_0_0_15_2 Node0_0_15 Node0_1_15 77.0
R_0_0_15_3 Node0_0_15 Node1_0_15 0.7700000000000001
I_0_0_16 GND Node0_0_16 0.48717948717948717A
R_0_0_16_1 Node0_0_16 Node0_0_17 77.0
R_0_0_16_2 Node0_0_16 Node0_1_16 77.0
R_0_0_16_3 Node0_0_16 Node1_0_16 0.7700000000000001
I_0_0_17 GND Node0_0_17 0.48717948717948717A
R_0_0_17_1 Node0_0_17 Node0_0_18 77.0
R_0_0_17_2 Node0_0_17 Node0_1_17 77.0
R_0_0_17_3 Node0_0_17 Node1_0_17 0.7700000000000001
I_0_0_18 GND Node0_0_18 0.48717948717948717A
R_0_0_18_1 Node0_0_18 Node0_0_19 76.99999999999996
R_0_0_18_2 Node0_0_18 Node0_1_18 77.0
R_0_0_18_3 Node0_0_18 Node1_0_18 0.7700000000000001
I_0_0_19 GND Node0_0_19 0.4871794871794877A
R_0_0_19_2 Node0_0_19 Node0_1_19 76.99999999999991
R_0_0_19_3 Node0_0_19 Node1_0_19 0.7699999999999994
I_0_1_0 GND Node0_1_0 0.48717948717948717A
R_0_1_0_1 Node0_1_0 Node0_1_1 77.0
R_0_1_0_2 Node0_1_0 Node0_2_0 77.0
R_0_1_0_3 Node0_1_0 Node1_1_0 0.7700000000000001
I_0_1_1 GND Node0_1_1 0.48717948717948717A
R_0_1_1_1 Node0_1_1 Node0_1_2 77.0
R_0_1_1_2 Node0_1_1 Node0_2_1 77.0
R_0_1_1_3 Node0_1_1 Node1_1_1 0.7700000000000001
I_0_1_2 GND Node0_1_2 0.48717948717948717A
R_0_1_2_1 Node0_1_2 Node0_1_3 77.0
R_0_1_2_2 Node0_1_2 Node0_2_2 77.0
R_0_1_2_3 Node0_1_2 Node1_1_2 0.7700000000000001
I_0_1_3 GND Node0_1_3 0.48717948717948717A
R_0_1_3_1 Node0_1_3 Node0_1_4 77.0
R_0_1_3_2 Node0_1_3 Node0_2_3 77.0
R_0_1_3_3 Node0_1_3 Node1_1_3 0.7700000000000001
I_0_1_4 GND Node0_1_4 0.48717948717948717A
R_0_1_4_1 Node0_1_4 Node0_1_5 77.0
R_0_1_4_2 Node0_1_4 Node0_2_4 77.0
R_0_1_4_3 Node0_1_4 Node1_1_4 0.7700000000000001
I_0_1_5 GND Node0_1_5 0.48717948717948717A
R_0_1_5_1 Node0_1_5 Node0_1_6 77.0
R_0_1_5_2 Node0_1_5 Node0_2_5 77.0
R_0_1_5_3 Node0_1_5 Node1_1_5 0.7700000000000001
I_0_1_6 GND Node0_1_6 0.48717948717948717A
R_0_1_6_1 Node0_1_6 Node0_1_7 77.0
R_0_1_6_2 Node0_1_6 Node0_2_6 77.0
R_0_1_6_3 Node0_1_6 Node1_1_6 0.7700000000000001
I_0_1_7 GND Node0_1_7 0.48717948717948717A
R_0_1_7_1 Node0_1_7 Node0_1_8 77.0
R_0_1_7_2 Node0_1_7 Node0_2_7 77.0
R_0_1_7_3 Node0_1_7 Node1_1_7 0.7700000000000001
I_0_1_8 GND Node0_1_8 0.48717948717948717A
R_0_1_8_1 Node0_1_8 Node0_1_9 77.0
R_0_1_8_2 Node0_1_8 Node0_2_8 77.0
R_0_1_8_3 Node0_1_8 Node1_1_8 0.7700000000000001
I_0_1_9 GND Node0_1_9 0.48717948717948717A
R_0_1_9_1 Node0_1_9 Node0_1_10 77.0
R_0_1_9_2 Node0_1_9 Node0_2_9 77.0
R_0_1_9_3 Node0_1_9 Node1_1_9 0.7700000000000001
I_0_1_10 GND Node0_1_10 0.48717948717948717A
R_0_1_10_1 Node0_1_10 Node0_1_11 77.0
R_0_1_10_2 Node0_1_10 Node0_2_10 77.0
R_0_1_10_3 Node0_1_10 Node1_1_10 0.7700000000000001
I_0_1_11 GND Node0_1_11 0.48717948717948717A
R_0_1_11_1 Node0_1_11 Node0_1_12 77.0
R_0_1_11_2 Node0_1_11 Node0_2_11 77.0
R_0_1_11_3 Node0_1_11 Node1_1_11 0.7700000000000001
I_0_1_12 GND Node0_1_12 0.48717948717948717A
R_0_1_12_1 Node0_1_12 Node0_1_13 77.0
R_0_1_12_2 Node0_1_12 Node0_2_12 77.0
R_0_1_12_3 Node0_1_12 Node1_1_12 0.7700000000000001
I_0_1_13 GND Node0_1_13 0.48717948717948717A
R_0_1_13_1 Node0_1_13 Node0_1_14 77.0
R_0_1_13_2 Node0_1_13 Node0_2_13 77.0
R_0_1_13_3 Node0_1_13 Node1_1_13 0.7700000000000001
I_0_1_14 GND Node0_1_14 0.48717948717948717A
R_0_1_14_1 Node0_1_14 Node0_1_15 77.0
R_0_1_14_2 Node0_1_14 Node0_2_14 77.0
R_0_1_14_3 Node0_1_14 Node1_1_14 0.7700000000000001
I_0_1_15 GND Node0_1_15 0.48717948717948717A
R_0_1_15_1 Node0_1_15 Node0_1_16 77.0
R_0_1_15_2 Node0_1_15 Node0_2_15 77.0
R_0_1_15_3 Node0_1_15 Node1_1_15 0.7700000000000001
I_0_1_16 GND Node0_1_16 0.48717948717948717A
R_0_1_16_1 Node0_1_16 Node0_1_17 77.0
R_0_1_16_2 Node0_1_16 Node0_2_16 77.0
R_0_1_16_3 Node0_1_16 Node1_1_16 0.7700000000000001
I_0_1_17 GND Node0_1_17 0.48717948717948717A
R_0_1_17_1 Node0_1_17 Node0_1_18 77.0
R_0_1_17_2 Node0_1_17 Node0_2_17 77.0
R_0_1_17_3 Node0_1_17 Node1_1_17 0.7700000000000001
I_0_1_18 GND Node0_1_18 0.48717948717948717A
R_0_1_18_1 Node0_1_18 Node0_1_19 76.99999999999997
R_0_1_18_2 Node0_1_18 Node0_2_18 77.0
R_0_1_18_3 Node0_1_18 Node1_1_18 0.7700000000000001
I_0_1_19 GND Node0_1_19 0.4871794871794876A
R_0_1_19_2 Node0_1_19 Node0_2_19 76.99999999999993
R_0_1_19_3 Node0_1_19 Node1_1_19 0.7699999999999995
I_0_2_0 GND Node0_2_0 0.48717948717948717A
R_0_2_0_1 Node0_2_0 Node0_2_1 77.0
R_0_2_0_2 Node0_2_0 Node0_3_0 77.0
R_0_2_0_3 Node0_2_0 Node1_2_0 0.7700000000000001
I_0_2_1 GND Node0_2_1 0.48717948717948717A
R_0_2_1_1 Node0_2_1 Node0_2_2 77.0
R_0_2_1_2 Node0_2_1 Node0_3_1 77.0
R_0_2_1_3 Node0_2_1 Node1_2_1 0.7700000000000001
I_0_2_2 GND Node0_2_2 0.48717948717948717A
R_0_2_2_1 Node0_2_2 Node0_2_3 77.0
R_0_2_2_2 Node0_2_2 Node0_3_2 77.0
R_0_2_2_3 Node0_2_2 Node1_2_2 0.7700000000000001
I_0_2_3 GND Node0_2_3 0.48717948717948717A
R_0_2_3_1 Node0_2_3 Node0_2_4 77.0
R_0_2_3_2 Node0_2_3 Node0_3_3 77.0
R_0_2_3_3 Node0_2_3 Node1_2_3 0.7700000000000001
I_0_2_4 GND Node0_2_4 0.48717948717948717A
R_0_2_4_1 Node0_2_4 Node0_2_5 77.0
R_0_2_4_2 Node0_2_4 Node0_3_4 77.0
R_0_2_4_3 Node0_2_4 Node1_2_4 0.7700000000000001
I_0_2_5 GND Node0_2_5 0.48717948717948717A
R_0_2_5_1 Node0_2_5 Node0_2_6 77.0
R_0_2_5_2 Node0_2_5 Node0_3_5 77.0
R_0_2_5_3 Node0_2_5 Node1_2_5 0.7700000000000001
I_0_2_6 GND Node0_2_6 0.48717948717948717A
R_0_2_6_1 Node0_2_6 Node0_2_7 77.0
R_0_2_6_2 Node0_2_6 Node0_3_6 77.0
R_0_2_6_3 Node0_2_6 Node1_2_6 0.7700000000000001
I_0_2_7 GND Node0_2_7 0.48717948717948717A
R_0_2_7_1 Node0_2_7 Node0_2_8 77.0
R_0_2_7_2 Node0_2_7 Node0_3_7 77.0
R_0_2_7_3 Node0_2_7 Node1_2_7 0.7700000000000001
I_0_2_8 GND Node0_2_8 0.48717948717948717A
R_0_2_8_1 Node0_2_8 Node0_2_9 77.0
R_0_2_8_2 Node0_2_8 Node0_3_8 77.0
R_0_2_8_3 Node0_2_8 Node1_2_8 0.7700000000000001
I_0_2_9 GND Node0_2_9 0.48717948717948717A
R_0_2_9_1 Node0_2_9 Node0_2_10 77.0
R_0_2_9_2 Node0_2_9 Node0_3_9 77.0
R_0_2_9_3 Node0_2_9 Node1_2_9 0.7700000000000001
I_0_2_10 GND Node0_2_10 0.48717948717948717A
R_0_2_10_1 Node0_2_10 Node0_2_11 77.0
R_0_2_10_2 Node0_2_10 Node0_3_10 77.0
R_0_2_10_3 Node0_2_10 Node1_2_10 0.7700000000000001
I_0_2_11 GND Node0_2_11 0.48717948717948717A
R_0_2_11_1 Node0_2_11 Node0_2_12 77.0
R_0_2_11_2 Node0_2_11 Node0_3_11 77.0
R_0_2_11_3 Node0_2_11 Node1_2_11 0.7700000000000001
I_0_2_12 GND Node0_2_12 0.48717948717948717A
R_0_2_12_1 Node0_2_12 Node0_2_13 77.0
R_0_2_12_2 Node0_2_12 Node0_3_12 77.0
R_0_2_12_3 Node0_2_12 Node1_2_12 0.7700000000000001
I_0_2_13 GND Node0_2_13 0.48717948717948717A
R_0_2_13_1 Node0_2_13 Node0_2_14 77.0
R_0_2_13_2 Node0_2_13 Node0_3_13 77.0
R_0_2_13_3 Node0_2_13 Node1_2_13 0.7700000000000001
I_0_2_14 GND Node0_2_14 0.48717948717948717A
R_0_2_14_1 Node0_2_14 Node0_2_15 77.0
R_0_2_14_2 Node0_2_14 Node0_3_14 77.0
R_0_2_14_3 Node0_2_14 Node1_2_14 0.7700000000000001
I_0_2_15 GND Node0_2_15 0.48717948717948717A
R_0_2_15_1 Node0_2_15 Node0_2_16 77.0
R_0_2_15_2 Node0_2_15 Node0_3_15 77.0
R_0_2_15_3 Node0_2_15 Node1_2_15 0.7700000000000001
I_0_2_16 GND Node0_2_16 0.48717948717948717A
R_0_2_16_1 Node0_2_16 Node0_2_17 77.0
R_0_2_16_2 Node0_2_16 Node0_3_16 77.0
R_0_2_16_3 Node0_2_16 Node1_2_16 0.7700000000000001
I_0_2_17 GND Node0_2_17 0.48717948717948717A
R_0_2_17_1 Node0_2_17 Node0_2_18 77.0
R_0_2_17_2 Node0_2_17 Node0_3_17 77.0
R_0_2_17_3 Node0_2_17 Node1_2_17 0.7700000000000001
I_0_2_18 GND Node0_2_18 0.48717948717948717A
R_0_2_18_1 Node0_2_18 Node0_2_19 76.99999999999997
R_0_2_18_2 Node0_2_18 Node0_3_18 77.0
R_0_2_18_3 Node0_2_18 Node1_2_18 0.7700000000000001
I_0_2_19 GND Node0_2_19 0.4871794871794876A
R_0_2_19_2 Node0_2_19 Node0_3_19 76.99999999999993
R_0_2_19_3 Node0_2_19 Node1_2_19 0.7699999999999995
I_0_3_0 GND Node0_3_0 0.48717948717948717A
R_0_3_0_1 Node0_3_0 Node0_3_1 77.0
R_0_3_0_2 Node0_3_0 Node0_4_0 77.0
R_0_3_0_3 Node0_3_0 Node1_3_0 0.7700000000000001
I_0_3_1 GND Node0_3_1 0.48717948717948717A
R_0_3_1_1 Node0_3_1 Node0_3_2 77.0
R_0_3_1_2 Node0_3_1 Node0_4_1 77.0
R_0_3_1_3 Node0_3_1 Node1_3_1 0.7700000000000001
I_0_3_2 GND Node0_3_2 0.48717948717948717A
R_0_3_2_1 Node0_3_2 Node0_3_3 77.0
R_0_3_2_2 Node0_3_2 Node0_4_2 77.0
R_0_3_2_3 Node0_3_2 Node1_3_2 0.7700000000000001
I_0_3_3 GND Node0_3_3 0.48717948717948717A
R_0_3_3_1 Node0_3_3 Node0_3_4 77.0
R_0_3_3_2 Node0_3_3 Node0_4_3 77.0
R_0_3_3_3 Node0_3_3 Node1_3_3 0.7700000000000001
I_0_3_4 GND Node0_3_4 0.48717948717948717A
R_0_3_4_1 Node0_3_4 Node0_3_5 77.0
R_0_3_4_2 Node0_3_4 Node0_4_4 77.0
R_0_3_4_3 Node0_3_4 Node1_3_4 0.7700000000000001
I_0_3_5 GND Node0_3_5 0.48717948717948717A
R_0_3_5_1 Node0_3_5 Node0_3_6 77.0
R_0_3_5_2 Node0_3_5 Node0_4_5 77.0
R_0_3_5_3 Node0_3_5 Node1_3_5 0.7700000000000001
I_0_3_6 GND Node0_3_6 0.48717948717948717A
R_0_3_6_1 Node0_3_6 Node0_3_7 77.0
R_0_3_6_2 Node0_3_6 Node0_4_6 77.0
R_0_3_6_3 Node0_3_6 Node1_3_6 0.7700000000000001
I_0_3_7 GND Node0_3_7 0.48717948717948717A
R_0_3_7_1 Node0_3_7 Node0_3_8 77.0
R_0_3_7_2 Node0_3_7 Node0_4_7 77.0
R_0_3_7_3 Node0_3_7 Node1_3_7 0.7700000000000001
I_0_3_8 GND Node0_3_8 0.48717948717948717A
R_0_3_8_1 Node0_3_8 Node0_3_9 77.0
R_0_3_8_2 Node0_3_8 Node0_4_8 77.0
R_0_3_8_3 Node0_3_8 Node1_3_8 0.7700000000000001
I_0_3_9 GND Node0_3_9 0.48717948717948717A
R_0_3_9_1 Node0_3_9 Node0_3_10 77.0
R_0_3_9_2 Node0_3_9 Node0_4_9 77.0
R_0_3_9_3 Node0_3_9 Node1_3_9 0.7700000000000001
I_0_3_10 GND Node0_3_10 0.48717948717948717A
R_0_3_10_1 Node0_3_10 Node0_3_11 77.0
R_0_3_10_2 Node0_3_10 Node0_4_10 77.0
R_0_3_10_3 Node0_3_10 Node1_3_10 0.7700000000000001
I_0_3_11 GND Node0_3_11 0.48717948717948717A
R_0_3_11_1 Node0_3_11 Node0_3_12 77.0
R_0_3_11_2 Node0_3_11 Node0_4_11 77.0
R_0_3_11_3 Node0_3_11 Node1_3_11 0.7700000000000001
I_0_3_12 GND Node0_3_12 0.48717948717948717A
R_0_3_12_1 Node0_3_12 Node0_3_13 77.0
R_0_3_12_2 Node0_3_12 Node0_4_12 77.0
R_0_3_12_3 Node0_3_12 Node1_3_12 0.7700000000000001
I_0_3_13 GND Node0_3_13 0.48717948717948717A
R_0_3_13_1 Node0_3_13 Node0_3_14 77.0
R_0_3_13_2 Node0_3_13 Node0_4_13 77.0
R_0_3_13_3 Node0_3_13 Node1_3_13 0.7700000000000001
I_0_3_14 GND Node0_3_14 0.48717948717948717A
R_0_3_14_1 Node0_3_14 Node0_3_15 77.0
R_0_3_14_2 Node0_3_14 Node0_4_14 77.0
R_0_3_14_3 Node0_3_14 Node1_3_14 0.7700000000000001
I_0_3_15 GND Node0_3_15 0.48717948717948717A
R_0_3_15_1 Node0_3_15 Node0_3_16 77.0
R_0_3_15_2 Node0_3_15 Node0_4_15 77.0
R_0_3_15_3 Node0_3_15 Node1_3_15 0.7700000000000001
I_0_3_16 GND Node0_3_16 0.48717948717948717A
R_0_3_16_1 Node0_3_16 Node0_3_17 77.0
R_0_3_16_2 Node0_3_16 Node0_4_16 77.0
R_0_3_16_3 Node0_3_16 Node1_3_16 0.7700000000000001
I_0_3_17 GND Node0_3_17 0.48717948717948717A
R_0_3_17_1 Node0_3_17 Node0_3_18 77.0
R_0_3_17_2 Node0_3_17 Node0_4_17 77.0
R_0_3_17_3 Node0_3_17 Node1_3_17 0.7700000000000001
I_0_3_18 GND Node0_3_18 0.48717948717948717A
R_0_3_18_1 Node0_3_18 Node0_3_19 76.99999999999997
R_0_3_18_2 Node0_3_18 Node0_4_18 77.0
R_0_3_18_3 Node0_3_18 Node1_3_18 0.7700000000000001
I_0_3_19 GND Node0_3_19 0.4871794871794876A
R_0_3_19_2 Node0_3_19 Node0_4_19 76.99999999999993
R_0_3_19_3 Node0_3_19 Node1_3_19 0.7699999999999995
I_0_4_0 GND Node0_4_0 0.48717948717948717A
R_0_4_0_1 Node0_4_0 Node0_4_1 77.0
R_0_4_0_2 Node0_4_0 Node0_5_0 77.0
R_0_4_0_3 Node0_4_0 Node1_4_0 0.7700000000000001
I_0_4_1 GND Node0_4_1 0.48717948717948717A
R_0_4_1_1 Node0_4_1 Node0_4_2 77.0
R_0_4_1_2 Node0_4_1 Node0_5_1 77.0
R_0_4_1_3 Node0_4_1 Node1_4_1 0.7700000000000001
I_0_4_2 GND Node0_4_2 0.48717948717948717A
R_0_4_2_1 Node0_4_2 Node0_4_3 77.0
R_0_4_2_2 Node0_4_2 Node0_5_2 77.0
R_0_4_2_3 Node0_4_2 Node1_4_2 0.7700000000000001
I_0_4_3 GND Node0_4_3 0.48717948717948717A
R_0_4_3_1 Node0_4_3 Node0_4_4 77.0
R_0_4_3_2 Node0_4_3 Node0_5_3 77.0
R_0_4_3_3 Node0_4_3 Node1_4_3 0.7700000000000001
I_0_4_4 GND Node0_4_4 0.48717948717948717A
R_0_4_4_1 Node0_4_4 Node0_4_5 77.0
R_0_4_4_2 Node0_4_4 Node0_5_4 77.0
R_0_4_4_3 Node0_4_4 Node1_4_4 0.7700000000000001
I_0_4_5 GND Node0_4_5 0.48717948717948717A
R_0_4_5_1 Node0_4_5 Node0_4_6 77.0
R_0_4_5_2 Node0_4_5 Node0_5_5 77.0
R_0_4_5_3 Node0_4_5 Node1_4_5 0.7700000000000001
I_0_4_6 GND Node0_4_6 0.48717948717948717A
R_0_4_6_1 Node0_4_6 Node0_4_7 77.0
R_0_4_6_2 Node0_4_6 Node0_5_6 77.0
R_0_4_6_3 Node0_4_6 Node1_4_6 0.7700000000000001
I_0_4_7 GND Node0_4_7 0.48717948717948717A
R_0_4_7_1 Node0_4_7 Node0_4_8 77.0
R_0_4_7_2 Node0_4_7 Node0_5_7 77.0
R_0_4_7_3 Node0_4_7 Node1_4_7 0.7700000000000001
I_0_4_8 GND Node0_4_8 0.48717948717948717A
R_0_4_8_1 Node0_4_8 Node0_4_9 77.0
R_0_4_8_2 Node0_4_8 Node0_5_8 77.0
R_0_4_8_3 Node0_4_8 Node1_4_8 0.7700000000000001
I_0_4_9 GND Node0_4_9 0.48717948717948717A
R_0_4_9_1 Node0_4_9 Node0_4_10 77.0
R_0_4_9_2 Node0_4_9 Node0_5_9 77.0
R_0_4_9_3 Node0_4_9 Node1_4_9 0.7700000000000001
I_0_4_10 GND Node0_4_10 0.48717948717948717A
R_0_4_10_1 Node0_4_10 Node0_4_11 77.0
R_0_4_10_2 Node0_4_10 Node0_5_10 77.0
R_0_4_10_3 Node0_4_10 Node1_4_10 0.7700000000000001
I_0_4_11 GND Node0_4_11 0.48717948717948717A
R_0_4_11_1 Node0_4_11 Node0_4_12 77.0
R_0_4_11_2 Node0_4_11 Node0_5_11 77.0
R_0_4_11_3 Node0_4_11 Node1_4_11 0.7700000000000001
I_0_4_12 GND Node0_4_12 0.48717948717948717A
R_0_4_12_1 Node0_4_12 Node0_4_13 77.0
R_0_4_12_2 Node0_4_12 Node0_5_12 77.0
R_0_4_12_3 Node0_4_12 Node1_4_12 0.7700000000000001
I_0_4_13 GND Node0_4_13 0.48717948717948717A
R_0_4_13_1 Node0_4_13 Node0_4_14 77.0
R_0_4_13_2 Node0_4_13 Node0_5_13 77.0
R_0_4_13_3 Node0_4_13 Node1_4_13 0.7700000000000001
I_0_4_14 GND Node0_4_14 0.48717948717948717A
R_0_4_14_1 Node0_4_14 Node0_4_15 77.0
R_0_4_14_2 Node0_4_14 Node0_5_14 77.0
R_0_4_14_3 Node0_4_14 Node1_4_14 0.7700000000000001
I_0_4_15 GND Node0_4_15 0.48717948717948717A
R_0_4_15_1 Node0_4_15 Node0_4_16 77.0
R_0_4_15_2 Node0_4_15 Node0_5_15 77.0
R_0_4_15_3 Node0_4_15 Node1_4_15 0.7700000000000001
I_0_4_16 GND Node0_4_16 0.48717948717948717A
R_0_4_16_1 Node0_4_16 Node0_4_17 77.0
R_0_4_16_2 Node0_4_16 Node0_5_16 77.0
R_0_4_16_3 Node0_4_16 Node1_4_16 0.7700000000000001
I_0_4_17 GND Node0_4_17 0.48717948717948717A
R_0_4_17_1 Node0_4_17 Node0_4_18 77.0
R_0_4_17_2 Node0_4_17 Node0_5_17 77.0
R_0_4_17_3 Node0_4_17 Node1_4_17 0.7700000000000001
I_0_4_18 GND Node0_4_18 0.48717948717948717A
R_0_4_18_1 Node0_4_18 Node0_4_19 76.99999999999997
R_0_4_18_2 Node0_4_18 Node0_5_18 77.0
R_0_4_18_3 Node0_4_18 Node1_4_18 0.7700000000000001
I_0_4_19 GND Node0_4_19 0.4871794871794876A
R_0_4_19_2 Node0_4_19 Node0_5_19 76.99999999999993
R_0_4_19_3 Node0_4_19 Node1_4_19 0.7699999999999995
I_0_5_0 GND Node0_5_0 0.48717948717948717A
R_0_5_0_1 Node0_5_0 Node0_5_1 77.0
R_0_5_0_2 Node0_5_0 Node0_6_0 77.0
R_0_5_0_3 Node0_5_0 Node1_5_0 0.7700000000000001
I_0_5_1 GND Node0_5_1 0.48717948717948717A
R_0_5_1_1 Node0_5_1 Node0_5_2 77.0
R_0_5_1_2 Node0_5_1 Node0_6_1 77.0
R_0_5_1_3 Node0_5_1 Node1_5_1 0.7700000000000001
I_0_5_2 GND Node0_5_2 0.48717948717948717A
R_0_5_2_1 Node0_5_2 Node0_5_3 77.0
R_0_5_2_2 Node0_5_2 Node0_6_2 77.0
R_0_5_2_3 Node0_5_2 Node1_5_2 0.7700000000000001
I_0_5_3 GND Node0_5_3 0.48717948717948717A
R_0_5_3_1 Node0_5_3 Node0_5_4 77.0
R_0_5_3_2 Node0_5_3 Node0_6_3 77.0
R_0_5_3_3 Node0_5_3 Node1_5_3 0.7700000000000001
I_0_5_4 GND Node0_5_4 0.48717948717948717A
R_0_5_4_1 Node0_5_4 Node0_5_5 77.0
R_0_5_4_2 Node0_5_4 Node0_6_4 77.0
R_0_5_4_3 Node0_5_4 Node1_5_4 0.7700000000000001
I_0_5_5 GND Node0_5_5 0.48717948717948717A
R_0_5_5_1 Node0_5_5 Node0_5_6 77.0
R_0_5_5_2 Node0_5_5 Node0_6_5 77.0
R_0_5_5_3 Node0_5_5 Node1_5_5 0.7700000000000001
I_0_5_6 GND Node0_5_6 0.48717948717948717A
R_0_5_6_1 Node0_5_6 Node0_5_7 77.0
R_0_5_6_2 Node0_5_6 Node0_6_6 77.0
R_0_5_6_3 Node0_5_6 Node1_5_6 0.7700000000000001
I_0_5_7 GND Node0_5_7 0.48717948717948717A
R_0_5_7_1 Node0_5_7 Node0_5_8 77.0
R_0_5_7_2 Node0_5_7 Node0_6_7 77.0
R_0_5_7_3 Node0_5_7 Node1_5_7 0.7700000000000001
I_0_5_8 GND Node0_5_8 0.48717948717948717A
R_0_5_8_1 Node0_5_8 Node0_5_9 77.0
R_0_5_8_2 Node0_5_8 Node0_6_8 77.0
R_0_5_8_3 Node0_5_8 Node1_5_8 0.7700000000000001
I_0_5_9 GND Node0_5_9 0.48717948717948717A
R_0_5_9_1 Node0_5_9 Node0_5_10 77.0
R_0_5_9_2 Node0_5_9 Node0_6_9 77.0
R_0_5_9_3 Node0_5_9 Node1_5_9 0.7700000000000001
I_0_5_10 GND Node0_5_10 0.48717948717948717A
R_0_5_10_1 Node0_5_10 Node0_5_11 77.0
R_0_5_10_2 Node0_5_10 Node0_6_10 77.0
R_0_5_10_3 Node0_5_10 Node1_5_10 0.7700000000000001
I_0_5_11 GND Node0_5_11 0.48717948717948717A
R_0_5_11_1 Node0_5_11 Node0_5_12 77.0
R_0_5_11_2 Node0_5_11 Node0_6_11 77.0
R_0_5_11_3 Node0_5_11 Node1_5_11 0.7700000000000001
I_0_5_12 GND Node0_5_12 0.48717948717948717A
R_0_5_12_1 Node0_5_12 Node0_5_13 77.0
R_0_5_12_2 Node0_5_12 Node0_6_12 77.0
R_0_5_12_3 Node0_5_12 Node1_5_12 0.7700000000000001
I_0_5_13 GND Node0_5_13 0.48717948717948717A
R_0_5_13_1 Node0_5_13 Node0_5_14 77.0
R_0_5_13_2 Node0_5_13 Node0_6_13 77.0
R_0_5_13_3 Node0_5_13 Node1_5_13 0.7700000000000001
I_0_5_14 GND Node0_5_14 0.48717948717948717A
R_0_5_14_1 Node0_5_14 Node0_5_15 77.0
R_0_5_14_2 Node0_5_14 Node0_6_14 77.0
R_0_5_14_3 Node0_5_14 Node1_5_14 0.7700000000000001
I_0_5_15 GND Node0_5_15 0.48717948717948717A
R_0_5_15_1 Node0_5_15 Node0_5_16 77.0
R_0_5_15_2 Node0_5_15 Node0_6_15 77.0
R_0_5_15_3 Node0_5_15 Node1_5_15 0.7700000000000001
I_0_5_16 GND Node0_5_16 0.48717948717948717A
R_0_5_16_1 Node0_5_16 Node0_5_17 77.0
R_0_5_16_2 Node0_5_16 Node0_6_16 77.0
R_0_5_16_3 Node0_5_16 Node1_5_16 0.7700000000000001
I_0_5_17 GND Node0_5_17 0.48717948717948717A
R_0_5_17_1 Node0_5_17 Node0_5_18 77.0
R_0_5_17_2 Node0_5_17 Node0_6_17 77.0
R_0_5_17_3 Node0_5_17 Node1_5_17 0.7700000000000001
I_0_5_18 GND Node0_5_18 0.48717948717948717A
R_0_5_18_1 Node0_5_18 Node0_5_19 76.99999999999997
R_0_5_18_2 Node0_5_18 Node0_6_18 77.0
R_0_5_18_3 Node0_5_18 Node1_5_18 0.7700000000000001
I_0_5_19 GND Node0_5_19 0.4871794871794876A
R_0_5_19_2 Node0_5_19 Node0_6_19 76.99999999999993
R_0_5_19_3 Node0_5_19 Node1_5_19 0.7699999999999995
I_0_6_0 GND Node0_6_0 0.48717948717948717A
R_0_6_0_1 Node0_6_0 Node0_6_1 77.0
R_0_6_0_2 Node0_6_0 Node0_7_0 77.0
R_0_6_0_3 Node0_6_0 Node1_6_0 0.7700000000000001
I_0_6_1 GND Node0_6_1 0.48717948717948717A
R_0_6_1_1 Node0_6_1 Node0_6_2 77.0
R_0_6_1_2 Node0_6_1 Node0_7_1 77.0
R_0_6_1_3 Node0_6_1 Node1_6_1 0.7700000000000001
I_0_6_2 GND Node0_6_2 0.48717948717948717A
R_0_6_2_1 Node0_6_2 Node0_6_3 77.0
R_0_6_2_2 Node0_6_2 Node0_7_2 77.0
R_0_6_2_3 Node0_6_2 Node1_6_2 0.7700000000000001
I_0_6_3 GND Node0_6_3 0.48717948717948717A
R_0_6_3_1 Node0_6_3 Node0_6_4 77.0
R_0_6_3_2 Node0_6_3 Node0_7_3 77.0
R_0_6_3_3 Node0_6_3 Node1_6_3 0.7700000000000001
I_0_6_4 GND Node0_6_4 0.48717948717948717A
R_0_6_4_1 Node0_6_4 Node0_6_5 77.0
R_0_6_4_2 Node0_6_4 Node0_7_4 77.0
R_0_6_4_3 Node0_6_4 Node1_6_4 0.7700000000000001
I_0_6_5 GND Node0_6_5 0.48717948717948717A
R_0_6_5_1 Node0_6_5 Node0_6_6 77.0
R_0_6_5_2 Node0_6_5 Node0_7_5 77.0
R_0_6_5_3 Node0_6_5 Node1_6_5 0.7700000000000001
I_0_6_6 GND Node0_6_6 0.48717948717948717A
R_0_6_6_1 Node0_6_6 Node0_6_7 77.0
R_0_6_6_2 Node0_6_6 Node0_7_6 77.0
R_0_6_6_3 Node0_6_6 Node1_6_6 0.7700000000000001
I_0_6_7 GND Node0_6_7 0.48717948717948717A
R_0_6_7_1 Node0_6_7 Node0_6_8 77.0
R_0_6_7_2 Node0_6_7 Node0_7_7 77.0
R_0_6_7_3 Node0_6_7 Node1_6_7 0.7700000000000001
I_0_6_8 GND Node0_6_8 0.48717948717948717A
R_0_6_8_1 Node0_6_8 Node0_6_9 77.0
R_0_6_8_2 Node0_6_8 Node0_7_8 77.0
R_0_6_8_3 Node0_6_8 Node1_6_8 0.7700000000000001
I_0_6_9 GND Node0_6_9 0.48717948717948717A
R_0_6_9_1 Node0_6_9 Node0_6_10 77.0
R_0_6_9_2 Node0_6_9 Node0_7_9 77.0
R_0_6_9_3 Node0_6_9 Node1_6_9 0.7700000000000001
I_0_6_10 GND Node0_6_10 0.48717948717948717A
R_0_6_10_1 Node0_6_10 Node0_6_11 77.0
R_0_6_10_2 Node0_6_10 Node0_7_10 77.0
R_0_6_10_3 Node0_6_10 Node1_6_10 0.7700000000000001
I_0_6_11 GND Node0_6_11 0.48717948717948717A
R_0_6_11_1 Node0_6_11 Node0_6_12 77.0
R_0_6_11_2 Node0_6_11 Node0_7_11 77.0
R_0_6_11_3 Node0_6_11 Node1_6_11 0.7700000000000001
I_0_6_12 GND Node0_6_12 0.48717948717948717A
R_0_6_12_1 Node0_6_12 Node0_6_13 77.0
R_0_6_12_2 Node0_6_12 Node0_7_12 77.0
R_0_6_12_3 Node0_6_12 Node1_6_12 0.7700000000000001
I_0_6_13 GND Node0_6_13 0.48717948717948717A
R_0_6_13_1 Node0_6_13 Node0_6_14 77.0
R_0_6_13_2 Node0_6_13 Node0_7_13 77.0
R_0_6_13_3 Node0_6_13 Node1_6_13 0.7700000000000001
I_0_6_14 GND Node0_6_14 0.48717948717948717A
R_0_6_14_1 Node0_6_14 Node0_6_15 77.0
R_0_6_14_2 Node0_6_14 Node0_7_14 77.0
R_0_6_14_3 Node0_6_14 Node1_6_14 0.7700000000000001
I_0_6_15 GND Node0_6_15 0.48717948717948717A
R_0_6_15_1 Node0_6_15 Node0_6_16 77.0
R_0_6_15_2 Node0_6_15 Node0_7_15 77.0
R_0_6_15_3 Node0_6_15 Node1_6_15 0.7700000000000001
I_0_6_16 GND Node0_6_16 0.48717948717948717A
R_0_6_16_1 Node0_6_16 Node0_6_17 77.0
R_0_6_16_2 Node0_6_16 Node0_7_16 77.0
R_0_6_16_3 Node0_6_16 Node1_6_16 0.7700000000000001
I_0_6_17 GND Node0_6_17 0.48717948717948717A
R_0_6_17_1 Node0_6_17 Node0_6_18 77.0
R_0_6_17_2 Node0_6_17 Node0_7_17 77.0
R_0_6_17_3 Node0_6_17 Node1_6_17 0.7700000000000001
I_0_6_18 GND Node0_6_18 0.48717948717948717A
R_0_6_18_1 Node0_6_18 Node0_6_19 76.99999999999997
R_0_6_18_2 Node0_6_18 Node0_7_18 77.0
R_0_6_18_3 Node0_6_18 Node1_6_18 0.7700000000000001
I_0_6_19 GND Node0_6_19 0.4871794871794876A
R_0_6_19_2 Node0_6_19 Node0_7_19 76.99999999999993
R_0_6_19_3 Node0_6_19 Node1_6_19 0.7699999999999995
I_0_7_0 GND Node0_7_0 0.48717948717948717A
R_0_7_0_1 Node0_7_0 Node0_7_1 77.0
R_0_7_0_2 Node0_7_0 Node0_8_0 77.0
R_0_7_0_3 Node0_7_0 Node1_7_0 0.7700000000000001
I_0_7_1 GND Node0_7_1 0.48717948717948717A
R_0_7_1_1 Node0_7_1 Node0_7_2 77.0
R_0_7_1_2 Node0_7_1 Node0_8_1 77.0
R_0_7_1_3 Node0_7_1 Node1_7_1 0.7700000000000001
I_0_7_2 GND Node0_7_2 0.48717948717948717A
R_0_7_2_1 Node0_7_2 Node0_7_3 77.0
R_0_7_2_2 Node0_7_2 Node0_8_2 77.0
R_0_7_2_3 Node0_7_2 Node1_7_2 0.7700000000000001
I_0_7_3 GND Node0_7_3 0.48717948717948717A
R_0_7_3_1 Node0_7_3 Node0_7_4 77.0
R_0_7_3_2 Node0_7_3 Node0_8_3 77.0
R_0_7_3_3 Node0_7_3 Node1_7_3 0.7700000000000001
I_0_7_4 GND Node0_7_4 0.48717948717948717A
R_0_7_4_1 Node0_7_4 Node0_7_5 77.0
R_0_7_4_2 Node0_7_4 Node0_8_4 77.0
R_0_7_4_3 Node0_7_4 Node1_7_4 0.7700000000000001
I_0_7_5 GND Node0_7_5 0.48717948717948717A
R_0_7_5_1 Node0_7_5 Node0_7_6 77.0
R_0_7_5_2 Node0_7_5 Node0_8_5 77.0
R_0_7_5_3 Node0_7_5 Node1_7_5 0.7700000000000001
I_0_7_6 GND Node0_7_6 0.48717948717948717A
R_0_7_6_1 Node0_7_6 Node0_7_7 77.0
R_0_7_6_2 Node0_7_6 Node0_8_6 77.0
R_0_7_6_3 Node0_7_6 Node1_7_6 0.7700000000000001
I_0_7_7 GND Node0_7_7 0.48717948717948717A
R_0_7_7_1 Node0_7_7 Node0_7_8 77.0
R_0_7_7_2 Node0_7_7 Node0_8_7 77.0
R_0_7_7_3 Node0_7_7 Node1_7_7 0.7700000000000001
I_0_7_8 GND Node0_7_8 0.48717948717948717A
R_0_7_8_1 Node0_7_8 Node0_7_9 77.0
R_0_7_8_2 Node0_7_8 Node0_8_8 77.0
R_0_7_8_3 Node0_7_8 Node1_7_8 0.7700000000000001
I_0_7_9 GND Node0_7_9 0.48717948717948717A
R_0_7_9_1 Node0_7_9 Node0_7_10 77.0
R_0_7_9_2 Node0_7_9 Node0_8_9 77.0
R_0_7_9_3 Node0_7_9 Node1_7_9 0.7700000000000001
I_0_7_10 GND Node0_7_10 0.48717948717948717A
R_0_7_10_1 Node0_7_10 Node0_7_11 77.0
R_0_7_10_2 Node0_7_10 Node0_8_10 77.0
R_0_7_10_3 Node0_7_10 Node1_7_10 0.7700000000000001
I_0_7_11 GND Node0_7_11 0.48717948717948717A
R_0_7_11_1 Node0_7_11 Node0_7_12 77.0
R_0_7_11_2 Node0_7_11 Node0_8_11 77.0
R_0_7_11_3 Node0_7_11 Node1_7_11 0.7700000000000001
I_0_7_12 GND Node0_7_12 0.48717948717948717A
R_0_7_12_1 Node0_7_12 Node0_7_13 77.0
R_0_7_12_2 Node0_7_12 Node0_8_12 77.0
R_0_7_12_3 Node0_7_12 Node1_7_12 0.7700000000000001
I_0_7_13 GND Node0_7_13 0.48717948717948717A
R_0_7_13_1 Node0_7_13 Node0_7_14 77.0
R_0_7_13_2 Node0_7_13 Node0_8_13 77.0
R_0_7_13_3 Node0_7_13 Node1_7_13 0.7700000000000001
I_0_7_14 GND Node0_7_14 0.48717948717948717A
R_0_7_14_1 Node0_7_14 Node0_7_15 77.0
R_0_7_14_2 Node0_7_14 Node0_8_14 77.0
R_0_7_14_3 Node0_7_14 Node1_7_14 0.7700000000000001
I_0_7_15 GND Node0_7_15 0.48717948717948717A
R_0_7_15_1 Node0_7_15 Node0_7_16 77.0
R_0_7_15_2 Node0_7_15 Node0_8_15 77.0
R_0_7_15_3 Node0_7_15 Node1_7_15 0.7700000000000001
I_0_7_16 GND Node0_7_16 0.48717948717948717A
R_0_7_16_1 Node0_7_16 Node0_7_17 77.0
R_0_7_16_2 Node0_7_16 Node0_8_16 77.0
R_0_7_16_3 Node0_7_16 Node1_7_16 0.7700000000000001
I_0_7_17 GND Node0_7_17 0.48717948717948717A
R_0_7_17_1 Node0_7_17 Node0_7_18 77.0
R_0_7_17_2 Node0_7_17 Node0_8_17 77.0
R_0_7_17_3 Node0_7_17 Node1_7_17 0.7700000000000001
I_0_7_18 GND Node0_7_18 0.48717948717948717A
R_0_7_18_1 Node0_7_18 Node0_7_19 76.99999999999997
R_0_7_18_2 Node0_7_18 Node0_8_18 77.0
R_0_7_18_3 Node0_7_18 Node1_7_18 0.7700000000000001
I_0_7_19 GND Node0_7_19 0.4871794871794876A
R_0_7_19_2 Node0_7_19 Node0_8_19 76.99999999999993
R_0_7_19_3 Node0_7_19 Node1_7_19 0.7699999999999995
I_0_8_0 GND Node0_8_0 0.48717948717948717A
R_0_8_0_1 Node0_8_0 Node0_8_1 77.0
R_0_8_0_2 Node0_8_0 Node0_9_0 77.00000000000003
R_0_8_0_3 Node0_8_0 Node1_8_0 0.7700000000000001
I_0_8_1 GND Node0_8_1 0.48717948717948717A
R_0_8_1_1 Node0_8_1 Node0_8_2 77.0
R_0_8_1_2 Node0_8_1 Node0_9_1 77.00000000000003
R_0_8_1_3 Node0_8_1 Node1_8_1 0.7700000000000001
I_0_8_2 GND Node0_8_2 0.48717948717948717A
R_0_8_2_1 Node0_8_2 Node0_8_3 77.0
R_0_8_2_2 Node0_8_2 Node0_9_2 77.00000000000003
R_0_8_2_3 Node0_8_2 Node1_8_2 0.7700000000000001
I_0_8_3 GND Node0_8_3 0.48717948717948717A
R_0_8_3_1 Node0_8_3 Node0_8_4 77.0
R_0_8_3_2 Node0_8_3 Node0_9_3 77.00000000000003
R_0_8_3_3 Node0_8_3 Node1_8_3 0.7700000000000001
I_0_8_4 GND Node0_8_4 0.48717948717948717A
R_0_8_4_1 Node0_8_4 Node0_8_5 77.0
R_0_8_4_2 Node0_8_4 Node0_9_4 77.00000000000003
R_0_8_4_3 Node0_8_4 Node1_8_4 0.7700000000000001
I_0_8_5 GND Node0_8_5 0.48717948717948717A
R_0_8_5_1 Node0_8_5 Node0_8_6 77.0
R_0_8_5_2 Node0_8_5 Node0_9_5 77.00000000000003
R_0_8_5_3 Node0_8_5 Node1_8_5 0.7700000000000001
I_0_8_6 GND Node0_8_6 0.48717948717948717A
R_0_8_6_1 Node0_8_6 Node0_8_7 77.0
R_0_8_6_2 Node0_8_6 Node0_9_6 77.00000000000003
R_0_8_6_3 Node0_8_6 Node1_8_6 0.7700000000000001
I_0_8_7 GND Node0_8_7 0.48717948717948717A
R_0_8_7_1 Node0_8_7 Node0_8_8 77.0
R_0_8_7_2 Node0_8_7 Node0_9_7 77.00000000000003
R_0_8_7_3 Node0_8_7 Node1_8_7 0.7700000000000001
I_0_8_8 GND Node0_8_8 0.48717948717948717A
R_0_8_8_1 Node0_8_8 Node0_8_9 77.0
R_0_8_8_2 Node0_8_8 Node0_9_8 77.00000000000003
R_0_8_8_3 Node0_8_8 Node1_8_8 0.7700000000000001
I_0_8_9 GND Node0_8_9 0.48717948717948717A
R_0_8_9_1 Node0_8_9 Node0_8_10 77.0
R_0_8_9_2 Node0_8_9 Node0_9_9 77.00000000000003
R_0_8_9_3 Node0_8_9 Node1_8_9 0.7700000000000001
I_0_8_10 GND Node0_8_10 0.48717948717948717A
R_0_8_10_1 Node0_8_10 Node0_8_11 77.0
R_0_8_10_2 Node0_8_10 Node0_9_10 77.00000000000003
R_0_8_10_3 Node0_8_10 Node1_8_10 0.7700000000000001
I_0_8_11 GND Node0_8_11 0.48717948717948717A
R_0_8_11_1 Node0_8_11 Node0_8_12 77.0
R_0_8_11_2 Node0_8_11 Node0_9_11 77.00000000000003
R_0_8_11_3 Node0_8_11 Node1_8_11 0.7700000000000001
I_0_8_12 GND Node0_8_12 0.48717948717948717A
R_0_8_12_1 Node0_8_12 Node0_8_13 77.0
R_0_8_12_2 Node0_8_12 Node0_9_12 77.00000000000003
R_0_8_12_3 Node0_8_12 Node1_8_12 0.7700000000000001
I_0_8_13 GND Node0_8_13 0.48717948717948717A
R_0_8_13_1 Node0_8_13 Node0_8_14 77.0
R_0_8_13_2 Node0_8_13 Node0_9_13 77.00000000000003
R_0_8_13_3 Node0_8_13 Node1_8_13 0.7700000000000001
I_0_8_14 GND Node0_8_14 0.48717948717948717A
R_0_8_14_1 Node0_8_14 Node0_8_15 77.0
R_0_8_14_2 Node0_8_14 Node0_9_14 77.00000000000003
R_0_8_14_3 Node0_8_14 Node1_8_14 0.7700000000000001
I_0_8_15 GND Node0_8_15 0.48717948717948717A
R_0_8_15_1 Node0_8_15 Node0_8_16 77.0
R_0_8_15_2 Node0_8_15 Node0_9_15 77.00000000000003
R_0_8_15_3 Node0_8_15 Node1_8_15 0.7700000000000001
I_0_8_16 GND Node0_8_16 0.48717948717948717A
R_0_8_16_1 Node0_8_16 Node0_8_17 77.0
R_0_8_16_2 Node0_8_16 Node0_9_16 77.00000000000003
R_0_8_16_3 Node0_8_16 Node1_8_16 0.7700000000000001
I_0_8_17 GND Node0_8_17 0.48717948717948717A
R_0_8_17_1 Node0_8_17 Node0_8_18 77.0
R_0_8_17_2 Node0_8_17 Node0_9_17 77.00000000000003
R_0_8_17_3 Node0_8_17 Node1_8_17 0.7700000000000001
I_0_8_18 GND Node0_8_18 0.48717948717948717A
R_0_8_18_1 Node0_8_18 Node0_8_19 76.99999999999997
R_0_8_18_2 Node0_8_18 Node0_9_18 77.00000000000003
R_0_8_18_3 Node0_8_18 Node1_8_18 0.7700000000000001
I_0_8_19 GND Node0_8_19 0.4871794871794876A
R_0_8_19_2 Node0_8_19 Node0_9_19 76.99999999999997
R_0_8_19_3 Node0_8_19 Node1_8_19 0.7699999999999995
I_0_9_0 GND Node0_9_0 0.6089743589743587A
R_0_9_0_1 Node0_9_0 Node0_9_1 77.00000000000006
R_0_9_0_2 Node0_9_0 Node0_10_0 77.00000000000006
R_0_9_0_3 Node0_9_0 Node1_9_0 0.7700000000000007
I_0_9_1 GND Node0_9_1 0.6089743589743587A
R_0_9_1_1 Node0_9_1 Node0_9_2 77.00000000000007
R_0_9_1_2 Node0_9_1 Node0_10_1 77.00000000000007
R_0_9_1_3 Node0_9_1 Node1_9_1 0.7700000000000008
I_0_9_2 GND Node0_9_2 0.6089743589743587A
R_0_9_2_1 Node0_9_2 Node0_9_3 77.00000000000007
R_0_9_2_2 Node0_9_2 Node0_10_2 77.00000000000007
R_0_9_2_3 Node0_9_2 Node1_9_2 0.7700000000000008
I_0_9_3 GND Node0_9_3 0.6089743589743587A
R_0_9_3_1 Node0_9_3 Node0_9_4 77.00000000000007
R_0_9_3_2 Node0_9_3 Node0_10_3 77.00000000000007
R_0_9_3_3 Node0_9_3 Node1_9_3 0.7700000000000008
I_0_9_4 GND Node0_9_4 0.6089743589743587A
R_0_9_4_1 Node0_9_4 Node0_9_5 77.00000000000007
R_0_9_4_2 Node0_9_4 Node0_10_4 77.00000000000007
R_0_9_4_3 Node0_9_4 Node1_9_4 0.7700000000000008
I_0_9_5 GND Node0_9_5 0.6089743589743587A
R_0_9_5_1 Node0_9_5 Node0_9_6 77.00000000000007
R_0_9_5_2 Node0_9_5 Node0_10_5 77.00000000000007
R_0_9_5_3 Node0_9_5 Node1_9_5 0.7700000000000008
I_0_9_6 GND Node0_9_6 0.6089743589743587A
R_0_9_6_1 Node0_9_6 Node0_9_7 77.00000000000007
R_0_9_6_2 Node0_9_6 Node0_10_6 77.00000000000007
R_0_9_6_3 Node0_9_6 Node1_9_6 0.7700000000000008
I_0_9_7 GND Node0_9_7 0.6089743589743587A
R_0_9_7_1 Node0_9_7 Node0_9_8 77.00000000000007
R_0_9_7_2 Node0_9_7 Node0_10_7 77.00000000000007
R_0_9_7_3 Node0_9_7 Node1_9_7 0.7700000000000008
I_0_9_8 GND Node0_9_8 0.6089743589743587A
R_0_9_8_1 Node0_9_8 Node0_9_9 77.00000000000007
R_0_9_8_2 Node0_9_8 Node0_10_8 77.00000000000007
R_0_9_8_3 Node0_9_8 Node1_9_8 0.7700000000000008
I_0_9_9 GND Node0_9_9 0.6730769230769227A
R_0_9_9_1 Node0_9_9 Node0_9_10 77.00000000000007
R_0_9_9_2 Node0_9_9 Node0_10_9 77.00000000000007
R_0_9_9_3 Node0_9_9 Node1_9_9 0.7700000000000009
I_0_9_10 GND Node0_9_10 0.6730769230769227A
R_0_9_10_1 Node0_9_10 Node0_9_11 77.00000000000007
R_0_9_10_2 Node0_9_10 Node0_10_10 77.00000000000007
R_0_9_10_3 Node0_9_10 Node1_9_10 0.7700000000000009
I_0_9_11 GND Node0_9_11 0.6089743589743587A
R_0_9_11_1 Node0_9_11 Node0_9_12 77.00000000000007
R_0_9_11_2 Node0_9_11 Node0_10_11 77.00000000000007
R_0_9_11_3 Node0_9_11 Node1_9_11 0.7700000000000008
I_0_9_12 GND Node0_9_12 0.6089743589743587A
R_0_9_12_1 Node0_9_12 Node0_9_13 77.00000000000007
R_0_9_12_2 Node0_9_12 Node0_10_12 77.00000000000007
R_0_9_12_3 Node0_9_12 Node1_9_12 0.7700000000000008
I_0_9_13 GND Node0_9_13 0.6089743589743587A
R_0_9_13_1 Node0_9_13 Node0_9_14 77.00000000000007
R_0_9_13_2 Node0_9_13 Node0_10_13 77.00000000000007
R_0_9_13_3 Node0_9_13 Node1_9_13 0.7700000000000008
I_0_9_14 GND Node0_9_14 0.6089743589743587A
R_0_9_14_1 Node0_9_14 Node0_9_15 77.00000000000007
R_0_9_14_2 Node0_9_14 Node0_10_14 77.00000000000007
R_0_9_14_3 Node0_9_14 Node1_9_14 0.7700000000000008
I_0_9_15 GND Node0_9_15 0.6089743589743587A
R_0_9_15_1 Node0_9_15 Node0_9_16 77.00000000000007
R_0_9_15_2 Node0_9_15 Node0_10_15 77.00000000000007
R_0_9_15_3 Node0_9_15 Node1_9_15 0.7700000000000008
I_0_9_16 GND Node0_9_16 0.6089743589743587A
R_0_9_16_1 Node0_9_16 Node0_9_17 77.00000000000007
R_0_9_16_2 Node0_9_16 Node0_10_16 77.00000000000007
R_0_9_16_3 Node0_9_16 Node1_9_16 0.7700000000000008
I_0_9_17 GND Node0_9_17 0.6089743589743587A
R_0_9_17_1 Node0_9_17 Node0_9_18 77.00000000000007
R_0_9_17_2 Node0_9_17 Node0_10_17 77.00000000000007
R_0_9_17_3 Node0_9_17 Node1_9_17 0.7700000000000008
I_0_9_18 GND Node0_9_18 0.6089743589743587A
R_0_9_18_1 Node0_9_18 Node0_9_19 77.00000000000003
R_0_9_18_2 Node0_9_18 Node0_10_18 77.00000000000007
R_0_9_18_3 Node0_9_18 Node1_9_18 0.7700000000000008
I_0_9_19 GND Node0_9_19 0.6089743589743593A
R_0_9_19_2 Node0_9_19 Node0_10_19 77.0
R_0_9_19_3 Node0_9_19 Node1_9_19 0.7700000000000001
I_0_10_0 GND Node0_10_0 0.6089743589743587A
R_0_10_0_1 Node0_10_0 Node0_10_1 77.00000000000006
R_0_10_0_2 Node0_10_0 Node0_11_0 77.00000000000003
R_0_10_0_3 Node0_10_0 Node1_10_0 0.7700000000000007
I_0_10_1 GND Node0_10_1 0.6089743589743587A
R_0_10_1_1 Node0_10_1 Node0_10_2 77.00000000000007
R_0_10_1_2 Node0_10_1 Node0_11_1 77.00000000000003
R_0_10_1_3 Node0_10_1 Node1_10_1 0.7700000000000008
I_0_10_2 GND Node0_10_2 0.6089743589743587A
R_0_10_2_1 Node0_10_2 Node0_10_3 77.00000000000007
R_0_10_2_2 Node0_10_2 Node0_11_2 77.00000000000003
R_0_10_2_3 Node0_10_2 Node1_10_2 0.7700000000000008
I_0_10_3 GND Node0_10_3 0.6089743589743587A
R_0_10_3_1 Node0_10_3 Node0_10_4 77.00000000000007
R_0_10_3_2 Node0_10_3 Node0_11_3 77.00000000000003
R_0_10_3_3 Node0_10_3 Node1_10_3 0.7700000000000008
I_0_10_4 GND Node0_10_4 0.6089743589743587A
R_0_10_4_1 Node0_10_4 Node0_10_5 77.00000000000007
R_0_10_4_2 Node0_10_4 Node0_11_4 77.00000000000003
R_0_10_4_3 Node0_10_4 Node1_10_4 0.7700000000000008
I_0_10_5 GND Node0_10_5 0.6089743589743587A
R_0_10_5_1 Node0_10_5 Node0_10_6 77.00000000000007
R_0_10_5_2 Node0_10_5 Node0_11_5 77.00000000000003
R_0_10_5_3 Node0_10_5 Node1_10_5 0.7700000000000008
I_0_10_6 GND Node0_10_6 0.6089743589743587A
R_0_10_6_1 Node0_10_6 Node0_10_7 77.00000000000007
R_0_10_6_2 Node0_10_6 Node0_11_6 77.00000000000003
R_0_10_6_3 Node0_10_6 Node1_10_6 0.7700000000000008
I_0_10_7 GND Node0_10_7 0.6089743589743587A
R_0_10_7_1 Node0_10_7 Node0_10_8 77.00000000000007
R_0_10_7_2 Node0_10_7 Node0_11_7 77.00000000000003
R_0_10_7_3 Node0_10_7 Node1_10_7 0.7700000000000008
I_0_10_8 GND Node0_10_8 0.6089743589743587A
R_0_10_8_1 Node0_10_8 Node0_10_9 77.00000000000007
R_0_10_8_2 Node0_10_8 Node0_11_8 77.00000000000003
R_0_10_8_3 Node0_10_8 Node1_10_8 0.7700000000000008
I_0_10_9 GND Node0_10_9 0.6730769230769227A
R_0_10_9_1 Node0_10_9 Node0_10_10 77.00000000000007
R_0_10_9_2 Node0_10_9 Node0_11_9 77.00000000000003
R_0_10_9_3 Node0_10_9 Node1_10_9 0.770000000000001
I_0_10_10 GND Node0_10_10 0.6730769230769227A
R_0_10_10_1 Node0_10_10 Node0_10_11 77.00000000000007
R_0_10_10_2 Node0_10_10 Node0_11_10 77.00000000000003
R_0_10_10_3 Node0_10_10 Node1_10_10 0.770000000000001
I_0_10_11 GND Node0_10_11 0.6089743589743587A
R_0_10_11_1 Node0_10_11 Node0_10_12 77.00000000000007
R_0_10_11_2 Node0_10_11 Node0_11_11 77.00000000000003
R_0_10_11_3 Node0_10_11 Node1_10_11 0.7700000000000008
I_0_10_12 GND Node0_10_12 0.6089743589743587A
R_0_10_12_1 Node0_10_12 Node0_10_13 77.00000000000007
R_0_10_12_2 Node0_10_12 Node0_11_12 77.00000000000003
R_0_10_12_3 Node0_10_12 Node1_10_12 0.7700000000000008
I_0_10_13 GND Node0_10_13 0.6089743589743587A
R_0_10_13_1 Node0_10_13 Node0_10_14 77.00000000000007
R_0_10_13_2 Node0_10_13 Node0_11_13 77.00000000000003
R_0_10_13_3 Node0_10_13 Node1_10_13 0.7700000000000008
I_0_10_14 GND Node0_10_14 0.6089743589743587A
R_0_10_14_1 Node0_10_14 Node0_10_15 77.00000000000007
R_0_10_14_2 Node0_10_14 Node0_11_14 77.00000000000003
R_0_10_14_3 Node0_10_14 Node1_10_14 0.7700000000000008
I_0_10_15 GND Node0_10_15 0.6089743589743587A
R_0_10_15_1 Node0_10_15 Node0_10_16 77.00000000000007
R_0_10_15_2 Node0_10_15 Node0_11_15 77.00000000000003
R_0_10_15_3 Node0_10_15 Node1_10_15 0.7700000000000008
I_0_10_16 GND Node0_10_16 0.6089743589743587A
R_0_10_16_1 Node0_10_16 Node0_10_17 77.00000000000007
R_0_10_16_2 Node0_10_16 Node0_11_16 77.00000000000003
R_0_10_16_3 Node0_10_16 Node1_10_16 0.7700000000000008
I_0_10_17 GND Node0_10_17 0.6089743589743587A
R_0_10_17_1 Node0_10_17 Node0_10_18 77.00000000000007
R_0_10_17_2 Node0_10_17 Node0_11_17 77.00000000000003
R_0_10_17_3 Node0_10_17 Node1_10_17 0.7700000000000008
I_0_10_18 GND Node0_10_18 0.6089743589743587A
R_0_10_18_1 Node0_10_18 Node0_10_19 77.00000000000003
R_0_10_18_2 Node0_10_18 Node0_11_18 77.00000000000003
R_0_10_18_3 Node0_10_18 Node1_10_18 0.7700000000000008
I_0_10_19 GND Node0_10_19 0.6089743589743593A
R_0_10_19_2 Node0_10_19 Node0_11_19 76.99999999999997
R_0_10_19_3 Node0_10_19 Node1_10_19 0.7700000000000001
I_0_11_0 GND Node0_11_0 0.48717948717948717A
R_0_11_0_1 Node0_11_0 Node0_11_1 77.0
R_0_11_0_2 Node0_11_0 Node0_12_0 77.0
R_0_11_0_3 Node0_11_0 Node1_11_0 0.7700000000000001
I_0_11_1 GND Node0_11_1 0.48717948717948717A
R_0_11_1_1 Node0_11_1 Node0_11_2 77.0
R_0_11_1_2 Node0_11_1 Node0_12_1 77.0
R_0_11_1_3 Node0_11_1 Node1_11_1 0.7700000000000001
I_0_11_2 GND Node0_11_2 0.48717948717948717A
R_0_11_2_1 Node0_11_2 Node0_11_3 77.0
R_0_11_2_2 Node0_11_2 Node0_12_2 77.0
R_0_11_2_3 Node0_11_2 Node1_11_2 0.7700000000000001
I_0_11_3 GND Node0_11_3 0.48717948717948717A
R_0_11_3_1 Node0_11_3 Node0_11_4 77.0
R_0_11_3_2 Node0_11_3 Node0_12_3 77.0
R_0_11_3_3 Node0_11_3 Node1_11_3 0.7700000000000001
I_0_11_4 GND Node0_11_4 0.48717948717948717A
R_0_11_4_1 Node0_11_4 Node0_11_5 77.0
R_0_11_4_2 Node0_11_4 Node0_12_4 77.0
R_0_11_4_3 Node0_11_4 Node1_11_4 0.7700000000000001
I_0_11_5 GND Node0_11_5 0.48717948717948717A
R_0_11_5_1 Node0_11_5 Node0_11_6 77.0
R_0_11_5_2 Node0_11_5 Node0_12_5 77.0
R_0_11_5_3 Node0_11_5 Node1_11_5 0.7700000000000001
I_0_11_6 GND Node0_11_6 0.48717948717948717A
R_0_11_6_1 Node0_11_6 Node0_11_7 77.0
R_0_11_6_2 Node0_11_6 Node0_12_6 77.0
R_0_11_6_3 Node0_11_6 Node1_11_6 0.7700000000000001
I_0_11_7 GND Node0_11_7 0.48717948717948717A
R_0_11_7_1 Node0_11_7 Node0_11_8 77.0
R_0_11_7_2 Node0_11_7 Node0_12_7 77.0
R_0_11_7_3 Node0_11_7 Node1_11_7 0.7700000000000001
I_0_11_8 GND Node0_11_8 0.48717948717948717A
R_0_11_8_1 Node0_11_8 Node0_11_9 77.0
R_0_11_8_2 Node0_11_8 Node0_12_8 77.0
R_0_11_8_3 Node0_11_8 Node1_11_8 0.7700000000000001
I_0_11_9 GND Node0_11_9 0.48717948717948717A
R_0_11_9_1 Node0_11_9 Node0_11_10 77.0
R_0_11_9_2 Node0_11_9 Node0_12_9 77.0
R_0_11_9_3 Node0_11_9 Node1_11_9 0.7700000000000001
I_0_11_10 GND Node0_11_10 0.48717948717948717A
R_0_11_10_1 Node0_11_10 Node0_11_11 77.0
R_0_11_10_2 Node0_11_10 Node0_12_10 77.0
R_0_11_10_3 Node0_11_10 Node1_11_10 0.7700000000000001
I_0_11_11 GND Node0_11_11 0.48717948717948717A
R_0_11_11_1 Node0_11_11 Node0_11_12 77.0
R_0_11_11_2 Node0_11_11 Node0_12_11 77.0
R_0_11_11_3 Node0_11_11 Node1_11_11 0.7700000000000001
I_0_11_12 GND Node0_11_12 0.48717948717948717A
R_0_11_12_1 Node0_11_12 Node0_11_13 77.0
R_0_11_12_2 Node0_11_12 Node0_12_12 77.0
R_0_11_12_3 Node0_11_12 Node1_11_12 0.7700000000000001
I_0_11_13 GND Node0_11_13 0.48717948717948717A
R_0_11_13_1 Node0_11_13 Node0_11_14 77.0
R_0_11_13_2 Node0_11_13 Node0_12_13 77.0
R_0_11_13_3 Node0_11_13 Node1_11_13 0.7700000000000001
I_0_11_14 GND Node0_11_14 0.48717948717948717A
R_0_11_14_1 Node0_11_14 Node0_11_15 77.0
R_0_11_14_2 Node0_11_14 Node0_12_14 77.0
R_0_11_14_3 Node0_11_14 Node1_11_14 0.7700000000000001
I_0_11_15 GND Node0_11_15 0.48717948717948717A
R_0_11_15_1 Node0_11_15 Node0_11_16 77.0
R_0_11_15_2 Node0_11_15 Node0_12_15 77.0
R_0_11_15_3 Node0_11_15 Node1_11_15 0.7700000000000001
I_0_11_16 GND Node0_11_16 0.48717948717948717A
R_0_11_16_1 Node0_11_16 Node0_11_17 77.0
R_0_11_16_2 Node0_11_16 Node0_12_16 77.0
R_0_11_16_3 Node0_11_16 Node1_11_16 0.7700000000000001
I_0_11_17 GND Node0_11_17 0.48717948717948717A
R_0_11_17_1 Node0_11_17 Node0_11_18 77.0
R_0_11_17_2 Node0_11_17 Node0_12_17 77.0
R_0_11_17_3 Node0_11_17 Node1_11_17 0.7700000000000001
I_0_11_18 GND Node0_11_18 0.48717948717948717A
R_0_11_18_1 Node0_11_18 Node0_11_19 76.99999999999997
R_0_11_18_2 Node0_11_18 Node0_12_18 77.0
R_0_11_18_3 Node0_11_18 Node1_11_18 0.7700000000000001
I_0_11_19 GND Node0_11_19 0.4871794871794876A
R_0_11_19_2 Node0_11_19 Node0_12_19 76.99999999999993
R_0_11_19_3 Node0_11_19 Node1_11_19 0.7699999999999995
I_0_12_0 GND Node0_12_0 0.48717948717948717A
R_0_12_0_1 Node0_12_0 Node0_12_1 77.0
R_0_12_0_2 Node0_12_0 Node0_13_0 77.0
R_0_12_0_3 Node0_12_0 Node1_12_0 0.7700000000000001
I_0_12_1 GND Node0_12_1 0.48717948717948717A
R_0_12_1_1 Node0_12_1 Node0_12_2 77.0
R_0_12_1_2 Node0_12_1 Node0_13_1 77.0
R_0_12_1_3 Node0_12_1 Node1_12_1 0.7700000000000001
I_0_12_2 GND Node0_12_2 0.48717948717948717A
R_0_12_2_1 Node0_12_2 Node0_12_3 77.0
R_0_12_2_2 Node0_12_2 Node0_13_2 77.0
R_0_12_2_3 Node0_12_2 Node1_12_2 0.7700000000000001
I_0_12_3 GND Node0_12_3 0.48717948717948717A
R_0_12_3_1 Node0_12_3 Node0_12_4 77.0
R_0_12_3_2 Node0_12_3 Node0_13_3 77.0
R_0_12_3_3 Node0_12_3 Node1_12_3 0.7700000000000001
I_0_12_4 GND Node0_12_4 0.48717948717948717A
R_0_12_4_1 Node0_12_4 Node0_12_5 77.0
R_0_12_4_2 Node0_12_4 Node0_13_4 77.0
R_0_12_4_3 Node0_12_4 Node1_12_4 0.7700000000000001
I_0_12_5 GND Node0_12_5 0.48717948717948717A
R_0_12_5_1 Node0_12_5 Node0_12_6 77.0
R_0_12_5_2 Node0_12_5 Node0_13_5 77.0
R_0_12_5_3 Node0_12_5 Node1_12_5 0.7700000000000001
I_0_12_6 GND Node0_12_6 0.48717948717948717A
R_0_12_6_1 Node0_12_6 Node0_12_7 77.0
R_0_12_6_2 Node0_12_6 Node0_13_6 77.0
R_0_12_6_3 Node0_12_6 Node1_12_6 0.7700000000000001
I_0_12_7 GND Node0_12_7 0.48717948717948717A
R_0_12_7_1 Node0_12_7 Node0_12_8 77.0
R_0_12_7_2 Node0_12_7 Node0_13_7 77.0
R_0_12_7_3 Node0_12_7 Node1_12_7 0.7700000000000001
I_0_12_8 GND Node0_12_8 0.48717948717948717A
R_0_12_8_1 Node0_12_8 Node0_12_9 77.0
R_0_12_8_2 Node0_12_8 Node0_13_8 77.0
R_0_12_8_3 Node0_12_8 Node1_12_8 0.7700000000000001
I_0_12_9 GND Node0_12_9 0.48717948717948717A
R_0_12_9_1 Node0_12_9 Node0_12_10 77.0
R_0_12_9_2 Node0_12_9 Node0_13_9 77.0
R_0_12_9_3 Node0_12_9 Node1_12_9 0.7700000000000001
I_0_12_10 GND Node0_12_10 0.48717948717948717A
R_0_12_10_1 Node0_12_10 Node0_12_11 77.0
R_0_12_10_2 Node0_12_10 Node0_13_10 77.0
R_0_12_10_3 Node0_12_10 Node1_12_10 0.7700000000000001
I_0_12_11 GND Node0_12_11 0.48717948717948717A
R_0_12_11_1 Node0_12_11 Node0_12_12 77.0
R_0_12_11_2 Node0_12_11 Node0_13_11 77.0
R_0_12_11_3 Node0_12_11 Node1_12_11 0.7700000000000001
I_0_12_12 GND Node0_12_12 0.48717948717948717A
R_0_12_12_1 Node0_12_12 Node0_12_13 77.0
R_0_12_12_2 Node0_12_12 Node0_13_12 77.0
R_0_12_12_3 Node0_12_12 Node1_12_12 0.7700000000000001
I_0_12_13 GND Node0_12_13 0.48717948717948717A
R_0_12_13_1 Node0_12_13 Node0_12_14 77.0
R_0_12_13_2 Node0_12_13 Node0_13_13 77.0
R_0_12_13_3 Node0_12_13 Node1_12_13 0.7700000000000001
I_0_12_14 GND Node0_12_14 0.48717948717948717A
R_0_12_14_1 Node0_12_14 Node0_12_15 77.0
R_0_12_14_2 Node0_12_14 Node0_13_14 77.0
R_0_12_14_3 Node0_12_14 Node1_12_14 0.7700000000000001
I_0_12_15 GND Node0_12_15 0.48717948717948717A
R_0_12_15_1 Node0_12_15 Node0_12_16 77.0
R_0_12_15_2 Node0_12_15 Node0_13_15 77.0
R_0_12_15_3 Node0_12_15 Node1_12_15 0.7700000000000001
I_0_12_16 GND Node0_12_16 0.48717948717948717A
R_0_12_16_1 Node0_12_16 Node0_12_17 77.0
R_0_12_16_2 Node0_12_16 Node0_13_16 77.0
R_0_12_16_3 Node0_12_16 Node1_12_16 0.7700000000000001
I_0_12_17 GND Node0_12_17 0.48717948717948717A
R_0_12_17_1 Node0_12_17 Node0_12_18 77.0
R_0_12_17_2 Node0_12_17 Node0_13_17 77.0
R_0_12_17_3 Node0_12_17 Node1_12_17 0.7700000000000001
I_0_12_18 GND Node0_12_18 0.48717948717948717A
R_0_12_18_1 Node0_12_18 Node0_12_19 76.99999999999997
R_0_12_18_2 Node0_12_18 Node0_13_18 77.0
R_0_12_18_3 Node0_12_18 Node1_12_18 0.7700000000000001
I_0_12_19 GND Node0_12_19 0.4871794871794876A
R_0_12_19_2 Node0_12_19 Node0_13_19 76.99999999999993
R_0_12_19_3 Node0_12_19 Node1_12_19 0.7699999999999995
I_0_13_0 GND Node0_13_0 0.48717948717948717A
R_0_13_0_1 Node0_13_0 Node0_13_1 77.0
R_0_13_0_2 Node0_13_0 Node0_14_0 77.0
R_0_13_0_3 Node0_13_0 Node1_13_0 0.7700000000000001
I_0_13_1 GND Node0_13_1 0.48717948717948717A
R_0_13_1_1 Node0_13_1 Node0_13_2 77.0
R_0_13_1_2 Node0_13_1 Node0_14_1 77.0
R_0_13_1_3 Node0_13_1 Node1_13_1 0.7700000000000001
I_0_13_2 GND Node0_13_2 0.48717948717948717A
R_0_13_2_1 Node0_13_2 Node0_13_3 77.0
R_0_13_2_2 Node0_13_2 Node0_14_2 77.0
R_0_13_2_3 Node0_13_2 Node1_13_2 0.7700000000000001
I_0_13_3 GND Node0_13_3 0.48717948717948717A
R_0_13_3_1 Node0_13_3 Node0_13_4 77.0
R_0_13_3_2 Node0_13_3 Node0_14_3 77.0
R_0_13_3_3 Node0_13_3 Node1_13_3 0.7700000000000001
I_0_13_4 GND Node0_13_4 0.48717948717948717A
R_0_13_4_1 Node0_13_4 Node0_13_5 77.0
R_0_13_4_2 Node0_13_4 Node0_14_4 77.0
R_0_13_4_3 Node0_13_4 Node1_13_4 0.7700000000000001
I_0_13_5 GND Node0_13_5 0.48717948717948717A
R_0_13_5_1 Node0_13_5 Node0_13_6 77.0
R_0_13_5_2 Node0_13_5 Node0_14_5 77.0
R_0_13_5_3 Node0_13_5 Node1_13_5 0.7700000000000001
I_0_13_6 GND Node0_13_6 0.48717948717948717A
R_0_13_6_1 Node0_13_6 Node0_13_7 77.0
R_0_13_6_2 Node0_13_6 Node0_14_6 77.0
R_0_13_6_3 Node0_13_6 Node1_13_6 0.7700000000000001
I_0_13_7 GND Node0_13_7 0.48717948717948717A
R_0_13_7_1 Node0_13_7 Node0_13_8 77.0
R_0_13_7_2 Node0_13_7 Node0_14_7 77.0
R_0_13_7_3 Node0_13_7 Node1_13_7 0.7700000000000001
I_0_13_8 GND Node0_13_8 0.48717948717948717A
R_0_13_8_1 Node0_13_8 Node0_13_9 77.0
R_0_13_8_2 Node0_13_8 Node0_14_8 77.0
R_0_13_8_3 Node0_13_8 Node1_13_8 0.7700000000000001
I_0_13_9 GND Node0_13_9 0.48717948717948717A
R_0_13_9_1 Node0_13_9 Node0_13_10 77.0
R_0_13_9_2 Node0_13_9 Node0_14_9 77.0
R_0_13_9_3 Node0_13_9 Node1_13_9 0.7700000000000001
I_0_13_10 GND Node0_13_10 0.48717948717948717A
R_0_13_10_1 Node0_13_10 Node0_13_11 77.0
R_0_13_10_2 Node0_13_10 Node0_14_10 77.0
R_0_13_10_3 Node0_13_10 Node1_13_10 0.7700000000000001
I_0_13_11 GND Node0_13_11 0.48717948717948717A
R_0_13_11_1 Node0_13_11 Node0_13_12 77.0
R_0_13_11_2 Node0_13_11 Node0_14_11 77.0
R_0_13_11_3 Node0_13_11 Node1_13_11 0.7700000000000001
I_0_13_12 GND Node0_13_12 0.48717948717948717A
R_0_13_12_1 Node0_13_12 Node0_13_13 77.0
R_0_13_12_2 Node0_13_12 Node0_14_12 77.0
R_0_13_12_3 Node0_13_12 Node1_13_12 0.7700000000000001
I_0_13_13 GND Node0_13_13 0.48717948717948717A
R_0_13_13_1 Node0_13_13 Node0_13_14 77.0
R_0_13_13_2 Node0_13_13 Node0_14_13 77.0
R_0_13_13_3 Node0_13_13 Node1_13_13 0.7700000000000001
I_0_13_14 GND Node0_13_14 0.48717948717948717A
R_0_13_14_1 Node0_13_14 Node0_13_15 77.0
R_0_13_14_2 Node0_13_14 Node0_14_14 77.0
R_0_13_14_3 Node0_13_14 Node1_13_14 0.7700000000000001
I_0_13_15 GND Node0_13_15 0.48717948717948717A
R_0_13_15_1 Node0_13_15 Node0_13_16 77.0
R_0_13_15_2 Node0_13_15 Node0_14_15 77.0
R_0_13_15_3 Node0_13_15 Node1_13_15 0.7700000000000001
I_0_13_16 GND Node0_13_16 0.48717948717948717A
R_0_13_16_1 Node0_13_16 Node0_13_17 77.0
R_0_13_16_2 Node0_13_16 Node0_14_16 77.0
R_0_13_16_3 Node0_13_16 Node1_13_16 0.7700000000000001
I_0_13_17 GND Node0_13_17 0.48717948717948717A
R_0_13_17_1 Node0_13_17 Node0_13_18 77.0
R_0_13_17_2 Node0_13_17 Node0_14_17 77.0
R_0_13_17_3 Node0_13_17 Node1_13_17 0.7700000000000001
I_0_13_18 GND Node0_13_18 0.48717948717948717A
R_0_13_18_1 Node0_13_18 Node0_13_19 76.99999999999997
R_0_13_18_2 Node0_13_18 Node0_14_18 77.0
R_0_13_18_3 Node0_13_18 Node1_13_18 0.7700000000000001
I_0_13_19 GND Node0_13_19 0.4871794871794876A
R_0_13_19_2 Node0_13_19 Node0_14_19 76.99999999999993
R_0_13_19_3 Node0_13_19 Node1_13_19 0.7699999999999995
I_0_14_0 GND Node0_14_0 0.48717948717948717A
R_0_14_0_1 Node0_14_0 Node0_14_1 77.0
R_0_14_0_2 Node0_14_0 Node0_15_0 77.0
R_0_14_0_3 Node0_14_0 Node1_14_0 0.7700000000000001
I_0_14_1 GND Node0_14_1 0.48717948717948717A
R_0_14_1_1 Node0_14_1 Node0_14_2 77.0
R_0_14_1_2 Node0_14_1 Node0_15_1 77.0
R_0_14_1_3 Node0_14_1 Node1_14_1 0.7700000000000001
I_0_14_2 GND Node0_14_2 0.48717948717948717A
R_0_14_2_1 Node0_14_2 Node0_14_3 77.0
R_0_14_2_2 Node0_14_2 Node0_15_2 77.0
R_0_14_2_3 Node0_14_2 Node1_14_2 0.7700000000000001
I_0_14_3 GND Node0_14_3 0.48717948717948717A
R_0_14_3_1 Node0_14_3 Node0_14_4 77.0
R_0_14_3_2 Node0_14_3 Node0_15_3 77.0
R_0_14_3_3 Node0_14_3 Node1_14_3 0.7700000000000001
I_0_14_4 GND Node0_14_4 0.48717948717948717A
R_0_14_4_1 Node0_14_4 Node0_14_5 77.0
R_0_14_4_2 Node0_14_4 Node0_15_4 77.0
R_0_14_4_3 Node0_14_4 Node1_14_4 0.7700000000000001
I_0_14_5 GND Node0_14_5 0.48717948717948717A
R_0_14_5_1 Node0_14_5 Node0_14_6 77.0
R_0_14_5_2 Node0_14_5 Node0_15_5 77.0
R_0_14_5_3 Node0_14_5 Node1_14_5 0.7700000000000001
I_0_14_6 GND Node0_14_6 0.48717948717948717A
R_0_14_6_1 Node0_14_6 Node0_14_7 77.0
R_0_14_6_2 Node0_14_6 Node0_15_6 77.0
R_0_14_6_3 Node0_14_6 Node1_14_6 0.7700000000000001
I_0_14_7 GND Node0_14_7 0.48717948717948717A
R_0_14_7_1 Node0_14_7 Node0_14_8 77.0
R_0_14_7_2 Node0_14_7 Node0_15_7 77.0
R_0_14_7_3 Node0_14_7 Node1_14_7 0.7700000000000001
I_0_14_8 GND Node0_14_8 0.48717948717948717A
R_0_14_8_1 Node0_14_8 Node0_14_9 77.0
R_0_14_8_2 Node0_14_8 Node0_15_8 77.0
R_0_14_8_3 Node0_14_8 Node1_14_8 0.7700000000000001
I_0_14_9 GND Node0_14_9 0.48717948717948717A
R_0_14_9_1 Node0_14_9 Node0_14_10 77.0
R_0_14_9_2 Node0_14_9 Node0_15_9 77.0
R_0_14_9_3 Node0_14_9 Node1_14_9 0.7700000000000001
I_0_14_10 GND Node0_14_10 0.48717948717948717A
R_0_14_10_1 Node0_14_10 Node0_14_11 77.0
R_0_14_10_2 Node0_14_10 Node0_15_10 77.0
R_0_14_10_3 Node0_14_10 Node1_14_10 0.7700000000000001
I_0_14_11 GND Node0_14_11 0.48717948717948717A
R_0_14_11_1 Node0_14_11 Node0_14_12 77.0
R_0_14_11_2 Node0_14_11 Node0_15_11 77.0
R_0_14_11_3 Node0_14_11 Node1_14_11 0.7700000000000001
I_0_14_12 GND Node0_14_12 0.48717948717948717A
R_0_14_12_1 Node0_14_12 Node0_14_13 77.0
R_0_14_12_2 Node0_14_12 Node0_15_12 77.0
R_0_14_12_3 Node0_14_12 Node1_14_12 0.7700000000000001
I_0_14_13 GND Node0_14_13 0.48717948717948717A
R_0_14_13_1 Node0_14_13 Node0_14_14 77.0
R_0_14_13_2 Node0_14_13 Node0_15_13 77.0
R_0_14_13_3 Node0_14_13 Node1_14_13 0.7700000000000001
I_0_14_14 GND Node0_14_14 0.48717948717948717A
R_0_14_14_1 Node0_14_14 Node0_14_15 77.0
R_0_14_14_2 Node0_14_14 Node0_15_14 77.0
R_0_14_14_3 Node0_14_14 Node1_14_14 0.7700000000000001
I_0_14_15 GND Node0_14_15 0.48717948717948717A
R_0_14_15_1 Node0_14_15 Node0_14_16 77.0
R_0_14_15_2 Node0_14_15 Node0_15_15 77.0
R_0_14_15_3 Node0_14_15 Node1_14_15 0.7700000000000001
I_0_14_16 GND Node0_14_16 0.48717948717948717A
R_0_14_16_1 Node0_14_16 Node0_14_17 77.0
R_0_14_16_2 Node0_14_16 Node0_15_16 77.0
R_0_14_16_3 Node0_14_16 Node1_14_16 0.7700000000000001
I_0_14_17 GND Node0_14_17 0.48717948717948717A
R_0_14_17_1 Node0_14_17 Node0_14_18 77.0
R_0_14_17_2 Node0_14_17 Node0_15_17 77.0
R_0_14_17_3 Node0_14_17 Node1_14_17 0.7700000000000001
I_0_14_18 GND Node0_14_18 0.48717948717948717A
R_0_14_18_1 Node0_14_18 Node0_14_19 76.99999999999997
R_0_14_18_2 Node0_14_18 Node0_15_18 77.0
R_0_14_18_3 Node0_14_18 Node1_14_18 0.7700000000000001
I_0_14_19 GND Node0_14_19 0.4871794871794876A
R_0_14_19_2 Node0_14_19 Node0_15_19 76.99999999999993
R_0_14_19_3 Node0_14_19 Node1_14_19 0.7699999999999995
I_0_15_0 GND Node0_15_0 0.48717948717948717A
R_0_15_0_1 Node0_15_0 Node0_15_1 77.0
R_0_15_0_2 Node0_15_0 Node0_16_0 77.0
R_0_15_0_3 Node0_15_0 Node1_15_0 0.7700000000000001
I_0_15_1 GND Node0_15_1 0.48717948717948717A
R_0_15_1_1 Node0_15_1 Node0_15_2 77.0
R_0_15_1_2 Node0_15_1 Node0_16_1 77.0
R_0_15_1_3 Node0_15_1 Node1_15_1 0.7700000000000001
I_0_15_2 GND Node0_15_2 0.48717948717948717A
R_0_15_2_1 Node0_15_2 Node0_15_3 77.0
R_0_15_2_2 Node0_15_2 Node0_16_2 77.0
R_0_15_2_3 Node0_15_2 Node1_15_2 0.7700000000000001
I_0_15_3 GND Node0_15_3 0.48717948717948717A
R_0_15_3_1 Node0_15_3 Node0_15_4 77.0
R_0_15_3_2 Node0_15_3 Node0_16_3 77.0
R_0_15_3_3 Node0_15_3 Node1_15_3 0.7700000000000001
I_0_15_4 GND Node0_15_4 0.48717948717948717A
R_0_15_4_1 Node0_15_4 Node0_15_5 77.0
R_0_15_4_2 Node0_15_4 Node0_16_4 77.0
R_0_15_4_3 Node0_15_4 Node1_15_4 0.7700000000000001
I_0_15_5 GND Node0_15_5 0.48717948717948717A
R_0_15_5_1 Node0_15_5 Node0_15_6 77.0
R_0_15_5_2 Node0_15_5 Node0_16_5 77.0
R_0_15_5_3 Node0_15_5 Node1_15_5 0.7700000000000001
I_0_15_6 GND Node0_15_6 0.48717948717948717A
R_0_15_6_1 Node0_15_6 Node0_15_7 77.0
R_0_15_6_2 Node0_15_6 Node0_16_6 77.0
R_0_15_6_3 Node0_15_6 Node1_15_6 0.7700000000000001
I_0_15_7 GND Node0_15_7 0.48717948717948717A
R_0_15_7_1 Node0_15_7 Node0_15_8 77.0
R_0_15_7_2 Node0_15_7 Node0_16_7 77.0
R_0_15_7_3 Node0_15_7 Node1_15_7 0.7700000000000001
I_0_15_8 GND Node0_15_8 0.48717948717948717A
R_0_15_8_1 Node0_15_8 Node0_15_9 77.0
R_0_15_8_2 Node0_15_8 Node0_16_8 77.0
R_0_15_8_3 Node0_15_8 Node1_15_8 0.7700000000000001
I_0_15_9 GND Node0_15_9 0.48717948717948717A
R_0_15_9_1 Node0_15_9 Node0_15_10 77.0
R_0_15_9_2 Node0_15_9 Node0_16_9 77.0
R_0_15_9_3 Node0_15_9 Node1_15_9 0.7700000000000001
I_0_15_10 GND Node0_15_10 0.48717948717948717A
R_0_15_10_1 Node0_15_10 Node0_15_11 77.0
R_0_15_10_2 Node0_15_10 Node0_16_10 77.0
R_0_15_10_3 Node0_15_10 Node1_15_10 0.7700000000000001
I_0_15_11 GND Node0_15_11 0.48717948717948717A
R_0_15_11_1 Node0_15_11 Node0_15_12 77.0
R_0_15_11_2 Node0_15_11 Node0_16_11 77.0
R_0_15_11_3 Node0_15_11 Node1_15_11 0.7700000000000001
I_0_15_12 GND Node0_15_12 0.48717948717948717A
R_0_15_12_1 Node0_15_12 Node0_15_13 77.0
R_0_15_12_2 Node0_15_12 Node0_16_12 77.0
R_0_15_12_3 Node0_15_12 Node1_15_12 0.7700000000000001
I_0_15_13 GND Node0_15_13 0.48717948717948717A
R_0_15_13_1 Node0_15_13 Node0_15_14 77.0
R_0_15_13_2 Node0_15_13 Node0_16_13 77.0
R_0_15_13_3 Node0_15_13 Node1_15_13 0.7700000000000001
I_0_15_14 GND Node0_15_14 0.48717948717948717A
R_0_15_14_1 Node0_15_14 Node0_15_15 77.0
R_0_15_14_2 Node0_15_14 Node0_16_14 77.0
R_0_15_14_3 Node0_15_14 Node1_15_14 0.7700000000000001
I_0_15_15 GND Node0_15_15 0.48717948717948717A
R_0_15_15_1 Node0_15_15 Node0_15_16 77.0
R_0_15_15_2 Node0_15_15 Node0_16_15 77.0
R_0_15_15_3 Node0_15_15 Node1_15_15 0.7700000000000001
I_0_15_16 GND Node0_15_16 0.48717948717948717A
R_0_15_16_1 Node0_15_16 Node0_15_17 77.0
R_0_15_16_2 Node0_15_16 Node0_16_16 77.0
R_0_15_16_3 Node0_15_16 Node1_15_16 0.7700000000000001
I_0_15_17 GND Node0_15_17 0.48717948717948717A
R_0_15_17_1 Node0_15_17 Node0_15_18 77.0
R_0_15_17_2 Node0_15_17 Node0_16_17 77.0
R_0_15_17_3 Node0_15_17 Node1_15_17 0.7700000000000001
I_0_15_18 GND Node0_15_18 0.48717948717948717A
R_0_15_18_1 Node0_15_18 Node0_15_19 76.99999999999997
R_0_15_18_2 Node0_15_18 Node0_16_18 77.0
R_0_15_18_3 Node0_15_18 Node1_15_18 0.7700000000000001
I_0_15_19 GND Node0_15_19 0.4871794871794876A
R_0_15_19_2 Node0_15_19 Node0_16_19 76.99999999999993
R_0_15_19_3 Node0_15_19 Node1_15_19 0.7699999999999995
I_0_16_0 GND Node0_16_0 0.48717948717948717A
R_0_16_0_1 Node0_16_0 Node0_16_1 77.0
R_0_16_0_2 Node0_16_0 Node0_17_0 77.0
R_0_16_0_3 Node0_16_0 Node1_16_0 0.7700000000000001
I_0_16_1 GND Node0_16_1 0.48717948717948717A
R_0_16_1_1 Node0_16_1 Node0_16_2 77.0
R_0_16_1_2 Node0_16_1 Node0_17_1 77.0
R_0_16_1_3 Node0_16_1 Node1_16_1 0.7700000000000001
I_0_16_2 GND Node0_16_2 0.48717948717948717A
R_0_16_2_1 Node0_16_2 Node0_16_3 77.0
R_0_16_2_2 Node0_16_2 Node0_17_2 77.0
R_0_16_2_3 Node0_16_2 Node1_16_2 0.7700000000000001
I_0_16_3 GND Node0_16_3 0.48717948717948717A
R_0_16_3_1 Node0_16_3 Node0_16_4 77.0
R_0_16_3_2 Node0_16_3 Node0_17_3 77.0
R_0_16_3_3 Node0_16_3 Node1_16_3 0.7700000000000001
I_0_16_4 GND Node0_16_4 0.48717948717948717A
R_0_16_4_1 Node0_16_4 Node0_16_5 77.0
R_0_16_4_2 Node0_16_4 Node0_17_4 77.0
R_0_16_4_3 Node0_16_4 Node1_16_4 0.7700000000000001
I_0_16_5 GND Node0_16_5 0.48717948717948717A
R_0_16_5_1 Node0_16_5 Node0_16_6 77.0
R_0_16_5_2 Node0_16_5 Node0_17_5 77.0
R_0_16_5_3 Node0_16_5 Node1_16_5 0.7700000000000001
I_0_16_6 GND Node0_16_6 0.48717948717948717A
R_0_16_6_1 Node0_16_6 Node0_16_7 77.0
R_0_16_6_2 Node0_16_6 Node0_17_6 77.0
R_0_16_6_3 Node0_16_6 Node1_16_6 0.7700000000000001
I_0_16_7 GND Node0_16_7 0.48717948717948717A
R_0_16_7_1 Node0_16_7 Node0_16_8 77.0
R_0_16_7_2 Node0_16_7 Node0_17_7 77.0
R_0_16_7_3 Node0_16_7 Node1_16_7 0.7700000000000001
I_0_16_8 GND Node0_16_8 0.48717948717948717A
R_0_16_8_1 Node0_16_8 Node0_16_9 77.0
R_0_16_8_2 Node0_16_8 Node0_17_8 77.0
R_0_16_8_3 Node0_16_8 Node1_16_8 0.7700000000000001
I_0_16_9 GND Node0_16_9 0.48717948717948717A
R_0_16_9_1 Node0_16_9 Node0_16_10 77.0
R_0_16_9_2 Node0_16_9 Node0_17_9 77.0
R_0_16_9_3 Node0_16_9 Node1_16_9 0.7700000000000001
I_0_16_10 GND Node0_16_10 0.48717948717948717A
R_0_16_10_1 Node0_16_10 Node0_16_11 77.0
R_0_16_10_2 Node0_16_10 Node0_17_10 77.0
R_0_16_10_3 Node0_16_10 Node1_16_10 0.7700000000000001
I_0_16_11 GND Node0_16_11 0.48717948717948717A
R_0_16_11_1 Node0_16_11 Node0_16_12 77.0
R_0_16_11_2 Node0_16_11 Node0_17_11 77.0
R_0_16_11_3 Node0_16_11 Node1_16_11 0.7700000000000001
I_0_16_12 GND Node0_16_12 0.48717948717948717A
R_0_16_12_1 Node0_16_12 Node0_16_13 77.0
R_0_16_12_2 Node0_16_12 Node0_17_12 77.0
R_0_16_12_3 Node0_16_12 Node1_16_12 0.7700000000000001
I_0_16_13 GND Node0_16_13 0.48717948717948717A
R_0_16_13_1 Node0_16_13 Node0_16_14 77.0
R_0_16_13_2 Node0_16_13 Node0_17_13 77.0
R_0_16_13_3 Node0_16_13 Node1_16_13 0.7700000000000001
I_0_16_14 GND Node0_16_14 0.48717948717948717A
R_0_16_14_1 Node0_16_14 Node0_16_15 77.0
R_0_16_14_2 Node0_16_14 Node0_17_14 77.0
R_0_16_14_3 Node0_16_14 Node1_16_14 0.7700000000000001
I_0_16_15 GND Node0_16_15 0.48717948717948717A
R_0_16_15_1 Node0_16_15 Node0_16_16 77.0
R_0_16_15_2 Node0_16_15 Node0_17_15 77.0
R_0_16_15_3 Node0_16_15 Node1_16_15 0.7700000000000001
I_0_16_16 GND Node0_16_16 0.48717948717948717A
R_0_16_16_1 Node0_16_16 Node0_16_17 77.0
R_0_16_16_2 Node0_16_16 Node0_17_16 77.0
R_0_16_16_3 Node0_16_16 Node1_16_16 0.7700000000000001
I_0_16_17 GND Node0_16_17 0.48717948717948717A
R_0_16_17_1 Node0_16_17 Node0_16_18 77.0
R_0_16_17_2 Node0_16_17 Node0_17_17 77.0
R_0_16_17_3 Node0_16_17 Node1_16_17 0.7700000000000001
I_0_16_18 GND Node0_16_18 0.48717948717948717A
R_0_16_18_1 Node0_16_18 Node0_16_19 76.99999999999997
R_0_16_18_2 Node0_16_18 Node0_17_18 77.0
R_0_16_18_3 Node0_16_18 Node1_16_18 0.7700000000000001
I_0_16_19 GND Node0_16_19 0.4871794871794876A
R_0_16_19_2 Node0_16_19 Node0_17_19 76.99999999999993
R_0_16_19_3 Node0_16_19 Node1_16_19 0.7699999999999995
I_0_17_0 GND Node0_17_0 0.48717948717948717A
R_0_17_0_1 Node0_17_0 Node0_17_1 77.0
R_0_17_0_2 Node0_17_0 Node0_18_0 77.0
R_0_17_0_3 Node0_17_0 Node1_17_0 0.7700000000000001
I_0_17_1 GND Node0_17_1 0.48717948717948717A
R_0_17_1_1 Node0_17_1 Node0_17_2 77.0
R_0_17_1_2 Node0_17_1 Node0_18_1 77.0
R_0_17_1_3 Node0_17_1 Node1_17_1 0.7700000000000001
I_0_17_2 GND Node0_17_2 0.48717948717948717A
R_0_17_2_1 Node0_17_2 Node0_17_3 77.0
R_0_17_2_2 Node0_17_2 Node0_18_2 77.0
R_0_17_2_3 Node0_17_2 Node1_17_2 0.7700000000000001
I_0_17_3 GND Node0_17_3 0.48717948717948717A
R_0_17_3_1 Node0_17_3 Node0_17_4 77.0
R_0_17_3_2 Node0_17_3 Node0_18_3 77.0
R_0_17_3_3 Node0_17_3 Node1_17_3 0.7700000000000001
I_0_17_4 GND Node0_17_4 0.48717948717948717A
R_0_17_4_1 Node0_17_4 Node0_17_5 77.0
R_0_17_4_2 Node0_17_4 Node0_18_4 77.0
R_0_17_4_3 Node0_17_4 Node1_17_4 0.7700000000000001
I_0_17_5 GND Node0_17_5 0.48717948717948717A
R_0_17_5_1 Node0_17_5 Node0_17_6 77.0
R_0_17_5_2 Node0_17_5 Node0_18_5 77.0
R_0_17_5_3 Node0_17_5 Node1_17_5 0.7700000000000001
I_0_17_6 GND Node0_17_6 0.48717948717948717A
R_0_17_6_1 Node0_17_6 Node0_17_7 77.0
R_0_17_6_2 Node0_17_6 Node0_18_6 77.0
R_0_17_6_3 Node0_17_6 Node1_17_6 0.7700000000000001
I_0_17_7 GND Node0_17_7 0.48717948717948717A
R_0_17_7_1 Node0_17_7 Node0_17_8 77.0
R_0_17_7_2 Node0_17_7 Node0_18_7 77.0
R_0_17_7_3 Node0_17_7 Node1_17_7 0.7700000000000001
I_0_17_8 GND Node0_17_8 0.48717948717948717A
R_0_17_8_1 Node0_17_8 Node0_17_9 77.0
R_0_17_8_2 Node0_17_8 Node0_18_8 77.0
R_0_17_8_3 Node0_17_8 Node1_17_8 0.7700000000000001
I_0_17_9 GND Node0_17_9 0.48717948717948717A
R_0_17_9_1 Node0_17_9 Node0_17_10 77.0
R_0_17_9_2 Node0_17_9 Node0_18_9 77.0
R_0_17_9_3 Node0_17_9 Node1_17_9 0.7700000000000001
I_0_17_10 GND Node0_17_10 0.48717948717948717A
R_0_17_10_1 Node0_17_10 Node0_17_11 77.0
R_0_17_10_2 Node0_17_10 Node0_18_10 77.0
R_0_17_10_3 Node0_17_10 Node1_17_10 0.7700000000000001
I_0_17_11 GND Node0_17_11 0.48717948717948717A
R_0_17_11_1 Node0_17_11 Node0_17_12 77.0
R_0_17_11_2 Node0_17_11 Node0_18_11 77.0
R_0_17_11_3 Node0_17_11 Node1_17_11 0.7700000000000001
I_0_17_12 GND Node0_17_12 0.48717948717948717A
R_0_17_12_1 Node0_17_12 Node0_17_13 77.0
R_0_17_12_2 Node0_17_12 Node0_18_12 77.0
R_0_17_12_3 Node0_17_12 Node1_17_12 0.7700000000000001
I_0_17_13 GND Node0_17_13 0.48717948717948717A
R_0_17_13_1 Node0_17_13 Node0_17_14 77.0
R_0_17_13_2 Node0_17_13 Node0_18_13 77.0
R_0_17_13_3 Node0_17_13 Node1_17_13 0.7700000000000001
I_0_17_14 GND Node0_17_14 0.48717948717948717A
R_0_17_14_1 Node0_17_14 Node0_17_15 77.0
R_0_17_14_2 Node0_17_14 Node0_18_14 77.0
R_0_17_14_3 Node0_17_14 Node1_17_14 0.7700000000000001
I_0_17_15 GND Node0_17_15 0.48717948717948717A
R_0_17_15_1 Node0_17_15 Node0_17_16 77.0
R_0_17_15_2 Node0_17_15 Node0_18_15 77.0
R_0_17_15_3 Node0_17_15 Node1_17_15 0.7700000000000001
I_0_17_16 GND Node0_17_16 0.48717948717948717A
R_0_17_16_1 Node0_17_16 Node0_17_17 77.0
R_0_17_16_2 Node0_17_16 Node0_18_16 77.0
R_0_17_16_3 Node0_17_16 Node1_17_16 0.7700000000000001
I_0_17_17 GND Node0_17_17 0.48717948717948717A
R_0_17_17_1 Node0_17_17 Node0_17_18 77.0
R_0_17_17_2 Node0_17_17 Node0_18_17 77.0
R_0_17_17_3 Node0_17_17 Node1_17_17 0.7700000000000001
I_0_17_18 GND Node0_17_18 0.48717948717948717A
R_0_17_18_1 Node0_17_18 Node0_17_19 76.99999999999997
R_0_17_18_2 Node0_17_18 Node0_18_18 77.0
R_0_17_18_3 Node0_17_18 Node1_17_18 0.7700000000000001
I_0_17_19 GND Node0_17_19 0.4871794871794876A
R_0_17_19_2 Node0_17_19 Node0_18_19 76.99999999999993
R_0_17_19_3 Node0_17_19 Node1_17_19 0.7699999999999995
I_0_18_0 GND Node0_18_0 0.48717948717948717A
R_0_18_0_1 Node0_18_0 Node0_18_1 77.0
R_0_18_0_2 Node0_18_0 Node0_19_0 77.0
R_0_18_0_3 Node0_18_0 Node1_18_0 0.7700000000000001
I_0_18_1 GND Node0_18_1 0.48717948717948717A
R_0_18_1_1 Node0_18_1 Node0_18_2 77.0
R_0_18_1_2 Node0_18_1 Node0_19_1 77.0
R_0_18_1_3 Node0_18_1 Node1_18_1 0.7700000000000001
I_0_18_2 GND Node0_18_2 0.48717948717948717A
R_0_18_2_1 Node0_18_2 Node0_18_3 77.0
R_0_18_2_2 Node0_18_2 Node0_19_2 77.0
R_0_18_2_3 Node0_18_2 Node1_18_2 0.7700000000000001
I_0_18_3 GND Node0_18_3 0.48717948717948717A
R_0_18_3_1 Node0_18_3 Node0_18_4 77.0
R_0_18_3_2 Node0_18_3 Node0_19_3 77.0
R_0_18_3_3 Node0_18_3 Node1_18_3 0.7700000000000001
I_0_18_4 GND Node0_18_4 0.48717948717948717A
R_0_18_4_1 Node0_18_4 Node0_18_5 77.0
R_0_18_4_2 Node0_18_4 Node0_19_4 77.0
R_0_18_4_3 Node0_18_4 Node1_18_4 0.7700000000000001
I_0_18_5 GND Node0_18_5 0.48717948717948717A
R_0_18_5_1 Node0_18_5 Node0_18_6 77.0
R_0_18_5_2 Node0_18_5 Node0_19_5 77.0
R_0_18_5_3 Node0_18_5 Node1_18_5 0.7700000000000001
I_0_18_6 GND Node0_18_6 0.48717948717948717A
R_0_18_6_1 Node0_18_6 Node0_18_7 77.0
R_0_18_6_2 Node0_18_6 Node0_19_6 77.0
R_0_18_6_3 Node0_18_6 Node1_18_6 0.7700000000000001
I_0_18_7 GND Node0_18_7 0.48717948717948717A
R_0_18_7_1 Node0_18_7 Node0_18_8 77.0
R_0_18_7_2 Node0_18_7 Node0_19_7 77.0
R_0_18_7_3 Node0_18_7 Node1_18_7 0.7700000000000001
I_0_18_8 GND Node0_18_8 0.48717948717948717A
R_0_18_8_1 Node0_18_8 Node0_18_9 77.0
R_0_18_8_2 Node0_18_8 Node0_19_8 77.0
R_0_18_8_3 Node0_18_8 Node1_18_8 0.7700000000000001
I_0_18_9 GND Node0_18_9 0.48717948717948717A
R_0_18_9_1 Node0_18_9 Node0_18_10 77.0
R_0_18_9_2 Node0_18_9 Node0_19_9 77.0
R_0_18_9_3 Node0_18_9 Node1_18_9 0.7700000000000001
I_0_18_10 GND Node0_18_10 0.48717948717948717A
R_0_18_10_1 Node0_18_10 Node0_18_11 77.0
R_0_18_10_2 Node0_18_10 Node0_19_10 77.0
R_0_18_10_3 Node0_18_10 Node1_18_10 0.7700000000000001
I_0_18_11 GND Node0_18_11 0.48717948717948717A
R_0_18_11_1 Node0_18_11 Node0_18_12 77.0
R_0_18_11_2 Node0_18_11 Node0_19_11 77.0
R_0_18_11_3 Node0_18_11 Node1_18_11 0.7700000000000001
I_0_18_12 GND Node0_18_12 0.48717948717948717A
R_0_18_12_1 Node0_18_12 Node0_18_13 77.0
R_0_18_12_2 Node0_18_12 Node0_19_12 77.0
R_0_18_12_3 Node0_18_12 Node1_18_12 0.7700000000000001
I_0_18_13 GND Node0_18_13 0.48717948717948717A
R_0_18_13_1 Node0_18_13 Node0_18_14 77.0
R_0_18_13_2 Node0_18_13 Node0_19_13 77.0
R_0_18_13_3 Node0_18_13 Node1_18_13 0.7700000000000001
I_0_18_14 GND Node0_18_14 0.48717948717948717A
R_0_18_14_1 Node0_18_14 Node0_18_15 77.0
R_0_18_14_2 Node0_18_14 Node0_19_14 77.0
R_0_18_14_3 Node0_18_14 Node1_18_14 0.7700000000000001
I_0_18_15 GND Node0_18_15 0.48717948717948717A
R_0_18_15_1 Node0_18_15 Node0_18_16 77.0
R_0_18_15_2 Node0_18_15 Node0_19_15 77.0
R_0_18_15_3 Node0_18_15 Node1_18_15 0.7700000000000001
I_0_18_16 GND Node0_18_16 0.48717948717948717A
R_0_18_16_1 Node0_18_16 Node0_18_17 77.0
R_0_18_16_2 Node0_18_16 Node0_19_16 77.0
R_0_18_16_3 Node0_18_16 Node1_18_16 0.7700000000000001
I_0_18_17 GND Node0_18_17 0.48717948717948717A
R_0_18_17_1 Node0_18_17 Node0_18_18 77.0
R_0_18_17_2 Node0_18_17 Node0_19_17 77.0
R_0_18_17_3 Node0_18_17 Node1_18_17 0.7700000000000001
I_0_18_18 GND Node0_18_18 0.48717948717948717A
R_0_18_18_1 Node0_18_18 Node0_18_19 76.99999999999997
R_0_18_18_2 Node0_18_18 Node0_19_18 77.0
R_0_18_18_3 Node0_18_18 Node1_18_18 0.7700000000000001
I_0_18_19 GND Node0_18_19 0.4871794871794876A
R_0_18_19_2 Node0_18_19 Node0_19_19 76.99999999999991
R_0_18_19_3 Node0_18_19 Node1_18_19 0.7699999999999995
I_0_19_0 GND Node0_19_0 0.48717948717948717A
R_0_19_0_1 Node0_19_0 Node0_19_1 77.0
R_0_19_0_3 Node0_19_0 Node1_19_0 0.7700000000000001
I_0_19_1 GND Node0_19_1 0.48717948717948717A
R_0_19_1_1 Node0_19_1 Node0_19_2 77.0
R_0_19_1_3 Node0_19_1 Node1_19_1 0.7700000000000001
I_0_19_2 GND Node0_19_2 0.48717948717948717A
R_0_19_2_1 Node0_19_2 Node0_19_3 77.0
R_0_19_2_3 Node0_19_2 Node1_19_2 0.7700000000000001
I_0_19_3 GND Node0_19_3 0.48717948717948717A
R_0_19_3_1 Node0_19_3 Node0_19_4 77.0
R_0_19_3_3 Node0_19_3 Node1_19_3 0.7700000000000001
I_0_19_4 GND Node0_19_4 0.48717948717948717A
R_0_19_4_1 Node0_19_4 Node0_19_5 77.0
R_0_19_4_3 Node0_19_4 Node1_19_4 0.7700000000000001
I_0_19_5 GND Node0_19_5 0.48717948717948717A
R_0_19_5_1 Node0_19_5 Node0_19_6 77.0
R_0_19_5_3 Node0_19_5 Node1_19_5 0.7700000000000001
I_0_19_6 GND Node0_19_6 0.48717948717948717A
R_0_19_6_1 Node0_19_6 Node0_19_7 77.0
R_0_19_6_3 Node0_19_6 Node1_19_6 0.7700000000000001
I_0_19_7 GND Node0_19_7 0.48717948717948717A
R_0_19_7_1 Node0_19_7 Node0_19_8 77.0
R_0_19_7_3 Node0_19_7 Node1_19_7 0.7700000000000001
I_0_19_8 GND Node0_19_8 0.48717948717948717A
R_0_19_8_1 Node0_19_8 Node0_19_9 77.0
R_0_19_8_3 Node0_19_8 Node1_19_8 0.7700000000000001
I_0_19_9 GND Node0_19_9 0.48717948717948717A
R_0_19_9_1 Node0_19_9 Node0_19_10 77.0
R_0_19_9_3 Node0_19_9 Node1_19_9 0.7700000000000001
I_0_19_10 GND Node0_19_10 0.48717948717948717A
R_0_19_10_1 Node0_19_10 Node0_19_11 77.0
R_0_19_10_3 Node0_19_10 Node1_19_10 0.7700000000000001
I_0_19_11 GND Node0_19_11 0.48717948717948717A
R_0_19_11_1 Node0_19_11 Node0_19_12 77.0
R_0_19_11_3 Node0_19_11 Node1_19_11 0.7700000000000001
I_0_19_12 GND Node0_19_12 0.48717948717948717A
R_0_19_12_1 Node0_19_12 Node0_19_13 77.0
R_0_19_12_3 Node0_19_12 Node1_19_12 0.7700000000000001
I_0_19_13 GND Node0_19_13 0.48717948717948717A
R_0_19_13_1 Node0_19_13 Node0_19_14 77.0
R_0_19_13_3 Node0_19_13 Node1_19_13 0.7700000000000001
I_0_19_14 GND Node0_19_14 0.48717948717948717A
R_0_19_14_1 Node0_19_14 Node0_19_15 77.0
R_0_19_14_3 Node0_19_14 Node1_19_14 0.7700000000000001
I_0_19_15 GND Node0_19_15 0.48717948717948717A
R_0_19_15_1 Node0_19_15 Node0_19_16 77.0
R_0_19_15_3 Node0_19_15 Node1_19_15 0.7700000000000001
I_0_19_16 GND Node0_19_16 0.48717948717948717A
R_0_19_16_1 Node0_19_16 Node0_19_17 77.0
R_0_19_16_3 Node0_19_16 Node1_19_16 0.7700000000000001
I_0_19_17 GND Node0_19_17 0.48717948717948717A
R_0_19_17_1 Node0_19_17 Node0_19_18 77.0
R_0_19_17_3 Node0_19_17 Node1_19_17 0.7700000000000001
I_0_19_18 GND Node0_19_18 0.48717948717948717A
R_0_19_18_1 Node0_19_18 Node0_19_19 76.99999999999996
R_0_19_18_3 Node0_19_18 Node1_19_18 0.7700000000000001
I_0_19_19 GND Node0_19_19 0.4871794871794877A
R_0_19_19_3 Node0_19_19 Node1_19_19 0.7699999999999994
R_1_0_0_1 Node1_0_0 Node1_0_1 250.00000000000003
R_1_0_0_2 Node1_0_0 Node1_1_0 250.00000000000003
R_1_0_0_3 Node1_0_0 GND 100.0
R_1_0_1_1 Node1_0_1 Node1_0_2 250.00000000000003
R_1_0_1_2 Node1_0_1 Node1_1_1 250.00000000000003
R_1_0_1_3 Node1_0_1 GND 100.0
R_1_0_2_1 Node1_0_2 Node1_0_3 250.00000000000003
R_1_0_2_2 Node1_0_2 Node1_1_2 250.00000000000003
R_1_0_2_3 Node1_0_2 GND 100.0
R_1_0_3_1 Node1_0_3 Node1_0_4 250.00000000000003
R_1_0_3_2 Node1_0_3 Node1_1_3 250.00000000000003
R_1_0_3_3 Node1_0_3 GND 100.0
R_1_0_4_1 Node1_0_4 Node1_0_5 250.00000000000003
R_1_0_4_2 Node1_0_4 Node1_1_4 250.00000000000003
R_1_0_4_3 Node1_0_4 GND 100.0
R_1_0_5_1 Node1_0_5 Node1_0_6 250.00000000000003
R_1_0_5_2 Node1_0_5 Node1_1_5 250.00000000000003
R_1_0_5_3 Node1_0_5 GND 100.0
R_1_0_6_1 Node1_0_6 Node1_0_7 250.00000000000003
R_1_0_6_2 Node1_0_6 Node1_1_6 250.00000000000003
R_1_0_6_3 Node1_0_6 GND 100.0
R_1_0_7_1 Node1_0_7 Node1_0_8 250.00000000000003
R_1_0_7_2 Node1_0_7 Node1_1_7 250.00000000000003
R_1_0_7_3 Node1_0_7 GND 100.0
R_1_0_8_1 Node1_0_8 Node1_0_9 250.00000000000003
R_1_0_8_2 Node1_0_8 Node1_1_8 250.00000000000003
R_1_0_8_3 Node1_0_8 GND 100.0
R_1_0_9_1 Node1_0_9 Node1_0_10 250.00000000000003
R_1_0_9_2 Node1_0_9 Node1_1_9 250.00000000000003
R_1_0_9_3 Node1_0_9 GND 100.0
R_1_0_10_1 Node1_0_10 Node1_0_11 250.00000000000003
R_1_0_10_2 Node1_0_10 Node1_1_10 250.00000000000003
R_1_0_10_3 Node1_0_10 GND 100.0
R_1_0_11_1 Node1_0_11 Node1_0_12 250.00000000000003
R_1_0_11_2 Node1_0_11 Node1_1_11 250.00000000000003
R_1_0_11_3 Node1_0_11 GND 100.0
R_1_0_12_1 Node1_0_12 Node1_0_13 250.00000000000003
R_1_0_12_2 Node1_0_12 Node1_1_12 250.00000000000003
R_1_0_12_3 Node1_0_12 GND 100.0
R_1_0_13_1 Node1_0_13 Node1_0_14 250.00000000000003
R_1_0_13_2 Node1_0_13 Node1_1_13 250.00000000000003
R_1_0_13_3 Node1_0_13 GND 100.0
R_1_0_14_1 Node1_0_14 Node1_0_15 250.00000000000003
R_1_0_14_2 Node1_0_14 Node1_1_14 250.00000000000003
R_1_0_14_3 Node1_0_14 GND 100.0
R_1_0_15_1 Node1_0_15 Node1_0_16 250.00000000000003
R_1_0_15_2 Node1_0_15 Node1_1_15 250.00000000000003
R_1_0_15_3 Node1_0_15 GND 100.0
R_1_0_16_1 Node1_0_16 Node1_0_17 250.00000000000003
R_1_0_16_2 Node1_0_16 Node1_1_16 250.00000000000003
R_1_0_16_3 Node1_0_16 GND 100.0
R_1_0_17_1 Node1_0_17 Node1_0_18 250.00000000000003
R_1_0_17_2 Node1_0_17 Node1_1_17 250.00000000000003
R_1_0_17_3 Node1_0_17 GND 100.0
R_1_0_18_1 Node1_0_18 Node1_0_19 250.00000000000003
R_1_0_18_2 Node1_0_18 Node1_1_18 250.00000000000003
R_1_0_18_3 Node1_0_18 GND 100.0
R_1_0_19_2 Node1_0_19 Node1_1_19 250.00000000000003
R_1_0_19_3 Node1_0_19 GND 100.0
R_1_1_0_1 Node1_1_0 Node1_1_1 250.00000000000003
R_1_1_0_2 Node1_1_0 Node1_2_0 250.00000000000003
R_1_1_0_3 Node1_1_0 GND 100.0
R_1_1_1_1 Node1_1_1 Node1_1_2 250.00000000000003
R_1_1_1_2 Node1_1_1 Node1_2_1 250.00000000000003
R_1_1_1_3 Node1_1_1 GND 100.0
R_1_1_2_1 Node1_1_2 Node1_1_3 250.00000000000003
R_1_1_2_2 Node1_1_2 Node1_2_2 250.00000000000003
R_1_1_2_3 Node1_1_2 GND 100.0
R_1_1_3_1 Node1_1_3 Node1_1_4 250.00000000000003
R_1_1_3_2 Node1_1_3 Node1_2_3 250.00000000000003
R_1_1_3_3 Node1_1_3 GND 100.0
R_1_1_4_1 Node1_1_4 Node1_1_5 250.00000000000003
R_1_1_4_2 Node1_1_4 Node1_2_4 250.00000000000003
R_1_1_4_3 Node1_1_4 GND 100.0
R_1_1_5_1 Node1_1_5 Node1_1_6 250.00000000000003
R_1_1_5_2 Node1_1_5 Node1_2_5 250.00000000000003
R_1_1_5_3 Node1_1_5 GND 100.0
R_1_1_6_1 Node1_1_6 Node1_1_7 250.00000000000003
R_1_1_6_2 Node1_1_6 Node1_2_6 250.00000000000003
R_1_1_6_3 Node1_1_6 GND 100.0
R_1_1_7_1 Node1_1_7 Node1_1_8 250.00000000000003
R_1_1_7_2 Node1_1_7 Node1_2_7 250.00000000000003
R_1_1_7_3 Node1_1_7 GND 100.0
R_1_1_8_1 Node1_1_8 Node1_1_9 250.00000000000003
R_1_1_8_2 Node1_1_8 Node1_2_8 250.00000000000003
R_1_1_8_3 Node1_1_8 GND 100.0
R_1_1_9_1 Node1_1_9 Node1_1_10 250.00000000000003
R_1_1_9_2 Node1_1_9 Node1_2_9 250.00000000000003
R_1_1_9_3 Node1_1_9 GND 100.0
R_1_1_10_1 Node1_1_10 Node1_1_11 250.00000000000003
R_1_1_10_2 Node1_1_10 Node1_2_10 250.00000000000003
R_1_1_10_3 Node1_1_10 GND 100.0
R_1_1_11_1 Node1_1_11 Node1_1_12 250.00000000000003
R_1_1_11_2 Node1_1_11 Node1_2_11 250.00000000000003
R_1_1_11_3 Node1_1_11 GND 100.0
R_1_1_12_1 Node1_1_12 Node1_1_13 250.00000000000003
R_1_1_12_2 Node1_1_12 Node1_2_12 250.00000000000003
R_1_1_12_3 Node1_1_12 GND 100.0
R_1_1_13_1 Node1_1_13 Node1_1_14 250.00000000000003
R_1_1_13_2 Node1_1_13 Node1_2_13 250.00000000000003
R_1_1_13_3 Node1_1_13 GND 100.0
R_1_1_14_1 Node1_1_14 Node1_1_15 250.00000000000003
R_1_1_14_2 Node1_1_14 Node1_2_14 250.00000000000003
R_1_1_14_3 Node1_1_14 GND 100.0
R_1_1_15_1 Node1_1_15 Node1_1_16 250.00000000000003
R_1_1_15_2 Node1_1_15 Node1_2_15 250.00000000000003
R_1_1_15_3 Node1_1_15 GND 100.0
R_1_1_16_1 Node1_1_16 Node1_1_17 250.00000000000003
R_1_1_16_2 Node1_1_16 Node1_2_16 250.00000000000003
R_1_1_16_3 Node1_1_16 GND 100.0
R_1_1_17_1 Node1_1_17 Node1_1_18 250.00000000000003
R_1_1_17_2 Node1_1_17 Node1_2_17 250.00000000000003
R_1_1_17_3 Node1_1_17 GND 100.0
R_1_1_18_1 Node1_1_18 Node1_1_19 250.00000000000003
R_1_1_18_2 Node1_1_18 Node1_2_18 250.00000000000003
R_1_1_18_3 Node1_1_18 GND 100.0
R_1_1_19_2 Node1_1_19 Node1_2_19 250.00000000000003
R_1_1_19_3 Node1_1_19 GND 100.0
R_1_2_0_1 Node1_2_0 Node1_2_1 250.00000000000003
R_1_2_0_2 Node1_2_0 Node1_3_0 250.00000000000003
R_1_2_0_3 Node1_2_0 GND 100.0
R_1_2_1_1 Node1_2_1 Node1_2_2 250.00000000000003
R_1_2_1_2 Node1_2_1 Node1_3_1 250.00000000000003
R_1_2_1_3 Node1_2_1 GND 100.0
R_1_2_2_1 Node1_2_2 Node1_2_3 250.00000000000003
R_1_2_2_2 Node1_2_2 Node1_3_2 250.00000000000003
R_1_2_2_3 Node1_2_2 GND 100.0
R_1_2_3_1 Node1_2_3 Node1_2_4 250.00000000000003
R_1_2_3_2 Node1_2_3 Node1_3_3 250.00000000000003
R_1_2_3_3 Node1_2_3 GND 100.0
R_1_2_4_1 Node1_2_4 Node1_2_5 250.00000000000003
R_1_2_4_2 Node1_2_4 Node1_3_4 250.00000000000003
R_1_2_4_3 Node1_2_4 GND 100.0
R_1_2_5_1 Node1_2_5 Node1_2_6 250.00000000000003
R_1_2_5_2 Node1_2_5 Node1_3_5 250.00000000000003
R_1_2_5_3 Node1_2_5 GND 100.0
R_1_2_6_1 Node1_2_6 Node1_2_7 250.00000000000003
R_1_2_6_2 Node1_2_6 Node1_3_6 250.00000000000003
R_1_2_6_3 Node1_2_6 GND 100.0
R_1_2_7_1 Node1_2_7 Node1_2_8 250.00000000000003
R_1_2_7_2 Node1_2_7 Node1_3_7 250.00000000000003
R_1_2_7_3 Node1_2_7 GND 100.0
R_1_2_8_1 Node1_2_8 Node1_2_9 250.00000000000003
R_1_2_8_2 Node1_2_8 Node1_3_8 250.00000000000003
R_1_2_8_3 Node1_2_8 GND 100.0
R_1_2_9_1 Node1_2_9 Node1_2_10 250.00000000000003
R_1_2_9_2 Node1_2_9 Node1_3_9 250.00000000000003
R_1_2_9_3 Node1_2_9 GND 100.0
R_1_2_10_1 Node1_2_10 Node1_2_11 250.00000000000003
R_1_2_10_2 Node1_2_10 Node1_3_10 250.00000000000003
R_1_2_10_3 Node1_2_10 GND 100.0
R_1_2_11_1 Node1_2_11 Node1_2_12 250.00000000000003
R_1_2_11_2 Node1_2_11 Node1_3_11 250.00000000000003
R_1_2_11_3 Node1_2_11 GND 100.0
R_1_2_12_1 Node1_2_12 Node1_2_13 250.00000000000003
R_1_2_12_2 Node1_2_12 Node1_3_12 250.00000000000003
R_1_2_12_3 Node1_2_12 GND 100.0
R_1_2_13_1 Node1_2_13 Node1_2_14 250.00000000000003
R_1_2_13_2 Node1_2_13 Node1_3_13 250.00000000000003
R_1_2_13_3 Node1_2_13 GND 100.0
R_1_2_14_1 Node1_2_14 Node1_2_15 250.00000000000003
R_1_2_14_2 Node1_2_14 Node1_3_14 250.00000000000003
R_1_2_14_3 Node1_2_14 GND 100.0
R_1_2_15_1 Node1_2_15 Node1_2_16 250.00000000000003
R_1_2_15_2 Node1_2_15 Node1_3_15 250.00000000000003
R_1_2_15_3 Node1_2_15 GND 100.0
R_1_2_16_1 Node1_2_16 Node1_2_17 250.00000000000003
R_1_2_16_2 Node1_2_16 Node1_3_16 250.00000000000003
R_1_2_16_3 Node1_2_16 GND 100.0
R_1_2_17_1 Node1_2_17 Node1_2_18 250.00000000000003
R_1_2_17_2 Node1_2_17 Node1_3_17 250.00000000000003
R_1_2_17_3 Node1_2_17 GND 100.0
R_1_2_18_1 Node1_2_18 Node1_2_19 250.00000000000003
R_1_2_18_2 Node1_2_18 Node1_3_18 250.00000000000003
R_1_2_18_3 Node1_2_18 GND 100.0
R_1_2_19_2 Node1_2_19 Node1_3_19 250.00000000000003
R_1_2_19_3 Node1_2_19 GND 100.0
R_1_3_0_1 Node1_3_0 Node1_3_1 250.00000000000003
R_1_3_0_2 Node1_3_0 Node1_4_0 250.00000000000003
R_1_3_0_3 Node1_3_0 GND 100.0
R_1_3_1_1 Node1_3_1 Node1_3_2 250.00000000000003
R_1_3_1_2 Node1_3_1 Node1_4_1 250.00000000000003
R_1_3_1_3 Node1_3_1 GND 100.0
R_1_3_2_1 Node1_3_2 Node1_3_3 250.00000000000003
R_1_3_2_2 Node1_3_2 Node1_4_2 250.00000000000003
R_1_3_2_3 Node1_3_2 GND 100.0
R_1_3_3_1 Node1_3_3 Node1_3_4 250.00000000000003
R_1_3_3_2 Node1_3_3 Node1_4_3 250.00000000000003
R_1_3_3_3 Node1_3_3 GND 100.0
R_1_3_4_1 Node1_3_4 Node1_3_5 250.00000000000003
R_1_3_4_2 Node1_3_4 Node1_4_4 250.00000000000003
R_1_3_4_3 Node1_3_4 GND 100.0
R_1_3_5_1 Node1_3_5 Node1_3_6 250.00000000000003
R_1_3_5_2 Node1_3_5 Node1_4_5 250.00000000000003
R_1_3_5_3 Node1_3_5 GND 100.0
R_1_3_6_1 Node1_3_6 Node1_3_7 250.00000000000003
R_1_3_6_2 Node1_3_6 Node1_4_6 250.00000000000003
R_1_3_6_3 Node1_3_6 GND 100.0
R_1_3_7_1 Node1_3_7 Node1_3_8 250.00000000000003
R_1_3_7_2 Node1_3_7 Node1_4_7 250.00000000000003
R_1_3_7_3 Node1_3_7 GND 100.0
R_1_3_8_1 Node1_3_8 Node1_3_9 250.00000000000003
R_1_3_8_2 Node1_3_8 Node1_4_8 250.00000000000003
R_1_3_8_3 Node1_3_8 GND 100.0
R_1_3_9_1 Node1_3_9 Node1_3_10 250.00000000000003
R_1_3_9_2 Node1_3_9 Node1_4_9 250.00000000000003
R_1_3_9_3 Node1_3_9 GND 100.0
R_1_3_10_1 Node1_3_10 Node1_3_11 250.00000000000003
R_1_3_10_2 Node1_3_10 Node1_4_10 250.00000000000003
R_1_3_10_3 Node1_3_10 GND 100.0
R_1_3_11_1 Node1_3_11 Node1_3_12 250.00000000000003
R_1_3_11_2 Node1_3_11 Node1_4_11 250.00000000000003
R_1_3_11_3 Node1_3_11 GND 100.0
R_1_3_12_1 Node1_3_12 Node1_3_13 250.00000000000003
R_1_3_12_2 Node1_3_12 Node1_4_12 250.00000000000003
R_1_3_12_3 Node1_3_12 GND 100.0
R_1_3_13_1 Node1_3_13 Node1_3_14 250.00000000000003
R_1_3_13_2 Node1_3_13 Node1_4_13 250.00000000000003
R_1_3_13_3 Node1_3_13 GND 100.0
R_1_3_14_1 Node1_3_14 Node1_3_15 250.00000000000003
R_1_3_14_2 Node1_3_14 Node1_4_14 250.00000000000003
R_1_3_14_3 Node1_3_14 GND 100.0
R_1_3_15_1 Node1_3_15 Node1_3_16 250.00000000000003
R_1_3_15_2 Node1_3_15 Node1_4_15 250.00000000000003
R_1_3_15_3 Node1_3_15 GND 100.0
R_1_3_16_1 Node1_3_16 Node1_3_17 250.00000000000003
R_1_3_16_2 Node1_3_16 Node1_4_16 250.00000000000003
R_1_3_16_3 Node1_3_16 GND 100.0
R_1_3_17_1 Node1_3_17 Node1_3_18 250.00000000000003
R_1_3_17_2 Node1_3_17 Node1_4_17 250.00000000000003
R_1_3_17_3 Node1_3_17 GND 100.0
R_1_3_18_1 Node1_3_18 Node1_3_19 250.00000000000003
R_1_3_18_2 Node1_3_18 Node1_4_18 250.00000000000003
R_1_3_18_3 Node1_3_18 GND 100.0
R_1_3_19_2 Node1_3_19 Node1_4_19 250.00000000000003
R_1_3_19_3 Node1_3_19 GND 100.0
R_1_4_0_1 Node1_4_0 Node1_4_1 250.00000000000003
R_1_4_0_2 Node1_4_0 Node1_5_0 250.00000000000003
R_1_4_0_3 Node1_4_0 GND 100.0
R_1_4_1_1 Node1_4_1 Node1_4_2 250.00000000000003
R_1_4_1_2 Node1_4_1 Node1_5_1 250.00000000000003
R_1_4_1_3 Node1_4_1 GND 100.0
R_1_4_2_1 Node1_4_2 Node1_4_3 250.00000000000003
R_1_4_2_2 Node1_4_2 Node1_5_2 250.00000000000003
R_1_4_2_3 Node1_4_2 GND 100.0
R_1_4_3_1 Node1_4_3 Node1_4_4 250.00000000000003
R_1_4_3_2 Node1_4_3 Node1_5_3 250.00000000000003
R_1_4_3_3 Node1_4_3 GND 100.0
R_1_4_4_1 Node1_4_4 Node1_4_5 250.00000000000003
R_1_4_4_2 Node1_4_4 Node1_5_4 250.00000000000003
R_1_4_4_3 Node1_4_4 GND 100.0
R_1_4_5_1 Node1_4_5 Node1_4_6 250.00000000000003
R_1_4_5_2 Node1_4_5 Node1_5_5 250.00000000000003
R_1_4_5_3 Node1_4_5 GND 100.0
R_1_4_6_1 Node1_4_6 Node1_4_7 250.00000000000003
R_1_4_6_2 Node1_4_6 Node1_5_6 250.00000000000003
R_1_4_6_3 Node1_4_6 GND 100.0
R_1_4_7_1 Node1_4_7 Node1_4_8 250.00000000000003
R_1_4_7_2 Node1_4_7 Node1_5_7 250.00000000000003
R_1_4_7_3 Node1_4_7 GND 100.0
R_1_4_8_1 Node1_4_8 Node1_4_9 250.00000000000003
R_1_4_8_2 Node1_4_8 Node1_5_8 250.00000000000003
R_1_4_8_3 Node1_4_8 GND 100.0
R_1_4_9_1 Node1_4_9 Node1_4_10 250.00000000000003
R_1_4_9_2 Node1_4_9 Node1_5_9 250.00000000000003
R_1_4_9_3 Node1_4_9 GND 100.0
R_1_4_10_1 Node1_4_10 Node1_4_11 250.00000000000003
R_1_4_10_2 Node1_4_10 Node1_5_10 250.00000000000003
R_1_4_10_3 Node1_4_10 GND 100.0
R_1_4_11_1 Node1_4_11 Node1_4_12 250.00000000000003
R_1_4_11_2 Node1_4_11 Node1_5_11 250.00000000000003
R_1_4_11_3 Node1_4_11 GND 100.0
R_1_4_12_1 Node1_4_12 Node1_4_13 250.00000000000003
R_1_4_12_2 Node1_4_12 Node1_5_12 250.00000000000003
R_1_4_12_3 Node1_4_12 GND 100.0
R_1_4_13_1 Node1_4_13 Node1_4_14 250.00000000000003
R_1_4_13_2 Node1_4_13 Node1_5_13 250.00000000000003
R_1_4_13_3 Node1_4_13 GND 100.0
R_1_4_14_1 Node1_4_14 Node1_4_15 250.00000000000003
R_1_4_14_2 Node1_4_14 Node1_5_14 250.00000000000003
R_1_4_14_3 Node1_4_14 GND 100.0
R_1_4_15_1 Node1_4_15 Node1_4_16 250.00000000000003
R_1_4_15_2 Node1_4_15 Node1_5_15 250.00000000000003
R_1_4_15_3 Node1_4_15 GND 100.0
R_1_4_16_1 Node1_4_16 Node1_4_17 250.00000000000003
R_1_4_16_2 Node1_4_16 Node1_5_16 250.00000000000003
R_1_4_16_3 Node1_4_16 GND 100.0
R_1_4_17_1 Node1_4_17 Node1_4_18 250.00000000000003
R_1_4_17_2 Node1_4_17 Node1_5_17 250.00000000000003
R_1_4_17_3 Node1_4_17 GND 100.0
R_1_4_18_1 Node1_4_18 Node1_4_19 250.00000000000003
R_1_4_18_2 Node1_4_18 Node1_5_18 250.00000000000003
R_1_4_18_3 Node1_4_18 GND 100.0
R_1_4_19_2 Node1_4_19 Node1_5_19 250.00000000000003
R_1_4_19_3 Node1_4_19 GND 100.0
R_1_5_0_1 Node1_5_0 Node1_5_1 250.00000000000003
R_1_5_0_2 Node1_5_0 Node1_6_0 250.00000000000003
R_1_5_0_3 Node1_5_0 GND 100.0
R_1_5_1_1 Node1_5_1 Node1_5_2 250.00000000000003
R_1_5_1_2 Node1_5_1 Node1_6_1 250.00000000000003
R_1_5_1_3 Node1_5_1 GND 100.0
R_1_5_2_1 Node1_5_2 Node1_5_3 250.00000000000003
R_1_5_2_2 Node1_5_2 Node1_6_2 250.00000000000003
R_1_5_2_3 Node1_5_2 GND 100.0
R_1_5_3_1 Node1_5_3 Node1_5_4 250.00000000000003
R_1_5_3_2 Node1_5_3 Node1_6_3 250.00000000000003
R_1_5_3_3 Node1_5_3 GND 100.0
R_1_5_4_1 Node1_5_4 Node1_5_5 250.00000000000003
R_1_5_4_2 Node1_5_4 Node1_6_4 250.00000000000003
R_1_5_4_3 Node1_5_4 GND 100.0
R_1_5_5_1 Node1_5_5 Node1_5_6 250.00000000000003
R_1_5_5_2 Node1_5_5 Node1_6_5 250.00000000000003
R_1_5_5_3 Node1_5_5 GND 100.0
R_1_5_6_1 Node1_5_6 Node1_5_7 250.00000000000003
R_1_5_6_2 Node1_5_6 Node1_6_6 250.00000000000003
R_1_5_6_3 Node1_5_6 GND 100.0
R_1_5_7_1 Node1_5_7 Node1_5_8 250.00000000000003
R_1_5_7_2 Node1_5_7 Node1_6_7 250.00000000000003
R_1_5_7_3 Node1_5_7 GND 100.0
R_1_5_8_1 Node1_5_8 Node1_5_9 250.00000000000003
R_1_5_8_2 Node1_5_8 Node1_6_8 250.00000000000003
R_1_5_8_3 Node1_5_8 GND 100.0
R_1_5_9_1 Node1_5_9 Node1_5_10 250.00000000000003
R_1_5_9_2 Node1_5_9 Node1_6_9 250.00000000000003
R_1_5_9_3 Node1_5_9 GND 100.0
R_1_5_10_1 Node1_5_10 Node1_5_11 250.00000000000003
R_1_5_10_2 Node1_5_10 Node1_6_10 250.00000000000003
R_1_5_10_3 Node1_5_10 GND 100.0
R_1_5_11_1 Node1_5_11 Node1_5_12 250.00000000000003
R_1_5_11_2 Node1_5_11 Node1_6_11 250.00000000000003
R_1_5_11_3 Node1_5_11 GND 100.0
R_1_5_12_1 Node1_5_12 Node1_5_13 250.00000000000003
R_1_5_12_2 Node1_5_12 Node1_6_12 250.00000000000003
R_1_5_12_3 Node1_5_12 GND 100.0
R_1_5_13_1 Node1_5_13 Node1_5_14 250.00000000000003
R_1_5_13_2 Node1_5_13 Node1_6_13 250.00000000000003
R_1_5_13_3 Node1_5_13 GND 100.0
R_1_5_14_1 Node1_5_14 Node1_5_15 250.00000000000003
R_1_5_14_2 Node1_5_14 Node1_6_14 250.00000000000003
R_1_5_14_3 Node1_5_14 GND 100.0
R_1_5_15_1 Node1_5_15 Node1_5_16 250.00000000000003
R_1_5_15_2 Node1_5_15 Node1_6_15 250.00000000000003
R_1_5_15_3 Node1_5_15 GND 100.0
R_1_5_16_1 Node1_5_16 Node1_5_17 250.00000000000003
R_1_5_16_2 Node1_5_16 Node1_6_16 250.00000000000003
R_1_5_16_3 Node1_5_16 GND 100.0
R_1_5_17_1 Node1_5_17 Node1_5_18 250.00000000000003
R_1_5_17_2 Node1_5_17 Node1_6_17 250.00000000000003
R_1_5_17_3 Node1_5_17 GND 100.0
R_1_5_18_1 Node1_5_18 Node1_5_19 250.00000000000003
R_1_5_18_2 Node1_5_18 Node1_6_18 250.00000000000003
R_1_5_18_3 Node1_5_18 GND 100.0
R_1_5_19_2 Node1_5_19 Node1_6_19 250.00000000000003
R_1_5_19_3 Node1_5_19 GND 100.0
R_1_6_0_1 Node1_6_0 Node1_6_1 250.00000000000003
R_1_6_0_2 Node1_6_0 Node1_7_0 250.00000000000003
R_1_6_0_3 Node1_6_0 GND 100.0
R_1_6_1_1 Node1_6_1 Node1_6_2 250.00000000000003
R_1_6_1_2 Node1_6_1 Node1_7_1 250.00000000000003
R_1_6_1_3 Node1_6_1 GND 100.0
R_1_6_2_1 Node1_6_2 Node1_6_3 250.00000000000003
R_1_6_2_2 Node1_6_2 Node1_7_2 250.00000000000003
R_1_6_2_3 Node1_6_2 GND 100.0
R_1_6_3_1 Node1_6_3 Node1_6_4 250.00000000000003
R_1_6_3_2 Node1_6_3 Node1_7_3 250.00000000000003
R_1_6_3_3 Node1_6_3 GND 100.0
R_1_6_4_1 Node1_6_4 Node1_6_5 250.00000000000003
R_1_6_4_2 Node1_6_4 Node1_7_4 250.00000000000003
R_1_6_4_3 Node1_6_4 GND 100.0
R_1_6_5_1 Node1_6_5 Node1_6_6 250.00000000000003
R_1_6_5_2 Node1_6_5 Node1_7_5 250.00000000000003
R_1_6_5_3 Node1_6_5 GND 100.0
R_1_6_6_1 Node1_6_6 Node1_6_7 250.00000000000003
R_1_6_6_2 Node1_6_6 Node1_7_6 250.00000000000003
R_1_6_6_3 Node1_6_6 GND 100.0
R_1_6_7_1 Node1_6_7 Node1_6_8 250.00000000000003
R_1_6_7_2 Node1_6_7 Node1_7_7 250.00000000000003
R_1_6_7_3 Node1_6_7 GND 100.0
R_1_6_8_1 Node1_6_8 Node1_6_9 250.00000000000003
R_1_6_8_2 Node1_6_8 Node1_7_8 250.00000000000003
R_1_6_8_3 Node1_6_8 GND 100.0
R_1_6_9_1 Node1_6_9 Node1_6_10 250.00000000000003
R_1_6_9_2 Node1_6_9 Node1_7_9 250.00000000000003
R_1_6_9_3 Node1_6_9 GND 100.0
R_1_6_10_1 Node1_6_10 Node1_6_11 250.00000000000003
R_1_6_10_2 Node1_6_10 Node1_7_10 250.00000000000003
R_1_6_10_3 Node1_6_10 GND 100.0
R_1_6_11_1 Node1_6_11 Node1_6_12 250.00000000000003
R_1_6_11_2 Node1_6_11 Node1_7_11 250.00000000000003
R_1_6_11_3 Node1_6_11 GND 100.0
R_1_6_12_1 Node1_6_12 Node1_6_13 250.00000000000003
R_1_6_12_2 Node1_6_12 Node1_7_12 250.00000000000003
R_1_6_12_3 Node1_6_12 GND 100.0
R_1_6_13_1 Node1_6_13 Node1_6_14 250.00000000000003
R_1_6_13_2 Node1_6_13 Node1_7_13 250.00000000000003
R_1_6_13_3 Node1_6_13 GND 100.0
R_1_6_14_1 Node1_6_14 Node1_6_15 250.00000000000003
R_1_6_14_2 Node1_6_14 Node1_7_14 250.00000000000003
R_1_6_14_3 Node1_6_14 GND 100.0
R_1_6_15_1 Node1_6_15 Node1_6_16 250.00000000000003
R_1_6_15_2 Node1_6_15 Node1_7_15 250.00000000000003
R_1_6_15_3 Node1_6_15 GND 100.0
R_1_6_16_1 Node1_6_16 Node1_6_17 250.00000000000003
R_1_6_16_2 Node1_6_16 Node1_7_16 250.00000000000003
R_1_6_16_3 Node1_6_16 GND 100.0
R_1_6_17_1 Node1_6_17 Node1_6_18 250.00000000000003
R_1_6_17_2 Node1_6_17 Node1_7_17 250.00000000000003
R_1_6_17_3 Node1_6_17 GND 100.0
R_1_6_18_1 Node1_6_18 Node1_6_19 250.00000000000003
R_1_6_18_2 Node1_6_18 Node1_7_18 250.00000000000003
R_1_6_18_3 Node1_6_18 GND 100.0
R_1_6_19_2 Node1_6_19 Node1_7_19 250.00000000000003
R_1_6_19_3 Node1_6_19 GND 100.0
R_1_7_0_1 Node1_7_0 Node1_7_1 250.00000000000003
R_1_7_0_2 Node1_7_0 Node1_8_0 250.00000000000003
R_1_7_0_3 Node1_7_0 GND 100.0
R_1_7_1_1 Node1_7_1 Node1_7_2 250.00000000000003
R_1_7_1_2 Node1_7_1 Node1_8_1 250.00000000000003
R_1_7_1_3 Node1_7_1 GND 100.0
R_1_7_2_1 Node1_7_2 Node1_7_3 250.00000000000003
R_1_7_2_2 Node1_7_2 Node1_8_2 250.00000000000003
R_1_7_2_3 Node1_7_2 GND 100.0
R_1_7_3_1 Node1_7_3 Node1_7_4 250.00000000000003
R_1_7_3_2 Node1_7_3 Node1_8_3 250.00000000000003
R_1_7_3_3 Node1_7_3 GND 100.0
R_1_7_4_1 Node1_7_4 Node1_7_5 250.00000000000003
R_1_7_4_2 Node1_7_4 Node1_8_4 250.00000000000003
R_1_7_4_3 Node1_7_4 GND 100.0
R_1_7_5_1 Node1_7_5 Node1_7_6 250.00000000000003
R_1_7_5_2 Node1_7_5 Node1_8_5 250.00000000000003
R_1_7_5_3 Node1_7_5 GND 100.0
R_1_7_6_1 Node1_7_6 Node1_7_7 250.00000000000003
R_1_7_6_2 Node1_7_6 Node1_8_6 250.00000000000003
R_1_7_6_3 Node1_7_6 GND 100.0
R_1_7_7_1 Node1_7_7 Node1_7_8 250.00000000000003
R_1_7_7_2 Node1_7_7 Node1_8_7 250.00000000000003
R_1_7_7_3 Node1_7_7 GND 100.0
R_1_7_8_1 Node1_7_8 Node1_7_9 250.00000000000003
R_1_7_8_2 Node1_7_8 Node1_8_8 250.00000000000003
R_1_7_8_3 Node1_7_8 GND 100.0
R_1_7_9_1 Node1_7_9 Node1_7_10 250.00000000000003
R_1_7_9_2 Node1_7_9 Node1_8_9 250.00000000000003
R_1_7_9_3 Node1_7_9 GND 100.0
R_1_7_10_1 Node1_7_10 Node1_7_11 250.00000000000003
R_1_7_10_2 Node1_7_10 Node1_8_10 250.00000000000003
R_1_7_10_3 Node1_7_10 GND 100.0
R_1_7_11_1 Node1_7_11 Node1_7_12 250.00000000000003
R_1_7_11_2 Node1_7_11 Node1_8_11 250.00000000000003
R_1_7_11_3 Node1_7_11 GND 100.0
R_1_7_12_1 Node1_7_12 Node1_7_13 250.00000000000003
R_1_7_12_2 Node1_7_12 Node1_8_12 250.00000000000003
R_1_7_12_3 Node1_7_12 GND 100.0
R_1_7_13_1 Node1_7_13 Node1_7_14 250.00000000000003
R_1_7_13_2 Node1_7_13 Node1_8_13 250.00000000000003
R_1_7_13_3 Node1_7_13 GND 100.0
R_1_7_14_1 Node1_7_14 Node1_7_15 250.00000000000003
R_1_7_14_2 Node1_7_14 Node1_8_14 250.00000000000003
R_1_7_14_3 Node1_7_14 GND 100.0
R_1_7_15_1 Node1_7_15 Node1_7_16 250.00000000000003
R_1_7_15_2 Node1_7_15 Node1_8_15 250.00000000000003
R_1_7_15_3 Node1_7_15 GND 100.0
R_1_7_16_1 Node1_7_16 Node1_7_17 250.00000000000003
R_1_7_16_2 Node1_7_16 Node1_8_16 250.00000000000003
R_1_7_16_3 Node1_7_16 GND 100.0
R_1_7_17_1 Node1_7_17 Node1_7_18 250.00000000000003
R_1_7_17_2 Node1_7_17 Node1_8_17 250.00000000000003
R_1_7_17_3 Node1_7_17 GND 100.0
R_1_7_18_1 Node1_7_18 Node1_7_19 250.00000000000003
R_1_7_18_2 Node1_7_18 Node1_8_18 250.00000000000003
R_1_7_18_3 Node1_7_18 GND 100.0
R_1_7_19_2 Node1_7_19 Node1_8_19 250.00000000000003
R_1_7_19_3 Node1_7_19 GND 100.0
R_1_8_0_1 Node1_8_0 Node1_8_1 250.00000000000003
R_1_8_0_2 Node1_8_0 Node1_9_0 250.00000000000003
R_1_8_0_3 Node1_8_0 GND 100.0
R_1_8_1_1 Node1_8_1 Node1_8_2 250.00000000000003
R_1_8_1_2 Node1_8_1 Node1_9_1 250.00000000000003
R_1_8_1_3 Node1_8_1 GND 100.0
R_1_8_2_1 Node1_8_2 Node1_8_3 250.00000000000003
R_1_8_2_2 Node1_8_2 Node1_9_2 250.00000000000003
R_1_8_2_3 Node1_8_2 GND 100.0
R_1_8_3_1 Node1_8_3 Node1_8_4 250.00000000000003
R_1_8_3_2 Node1_8_3 Node1_9_3 250.00000000000003
R_1_8_3_3 Node1_8_3 GND 100.0
R_1_8_4_1 Node1_8_4 Node1_8_5 250.00000000000003
R_1_8_4_2 Node1_8_4 Node1_9_4 250.00000000000003
R_1_8_4_3 Node1_8_4 GND 100.0
R_1_8_5_1 Node1_8_5 Node1_8_6 250.00000000000003
R_1_8_5_2 Node1_8_5 Node1_9_5 250.00000000000003
R_1_8_5_3 Node1_8_5 GND 100.0
R_1_8_6_1 Node1_8_6 Node1_8_7 250.00000000000003
R_1_8_6_2 Node1_8_6 Node1_9_6 250.00000000000003
R_1_8_6_3 Node1_8_6 GND 100.0
R_1_8_7_1 Node1_8_7 Node1_8_8 250.00000000000003
R_1_8_7_2 Node1_8_7 Node1_9_7 250.00000000000003
R_1_8_7_3 Node1_8_7 GND 100.0
R_1_8_8_1 Node1_8_8 Node1_8_9 250.00000000000003
R_1_8_8_2 Node1_8_8 Node1_9_8 250.00000000000003
R_1_8_8_3 Node1_8_8 GND 100.0
R_1_8_9_1 Node1_8_9 Node1_8_10 250.00000000000003
R_1_8_9_2 Node1_8_9 Node1_9_9 250.00000000000003
R_1_8_9_3 Node1_8_9 GND 100.0
R_1_8_10_1 Node1_8_10 Node1_8_11 250.00000000000003
R_1_8_10_2 Node1_8_10 Node1_9_10 250.00000000000003
R_1_8_10_3 Node1_8_10 GND 100.0
R_1_8_11_1 Node1_8_11 Node1_8_12 250.00000000000003
R_1_8_11_2 Node1_8_11 Node1_9_11 250.00000000000003
R_1_8_11_3 Node1_8_11 GND 100.0
R_1_8_12_1 Node1_8_12 Node1_8_13 250.00000000000003
R_1_8_12_2 Node1_8_12 Node1_9_12 250.00000000000003
R_1_8_12_3 Node1_8_12 GND 100.0
R_1_8_13_1 Node1_8_13 Node1_8_14 250.00000000000003
R_1_8_13_2 Node1_8_13 Node1_9_13 250.00000000000003
R_1_8_13_3 Node1_8_13 GND 100.0
R_1_8_14_1 Node1_8_14 Node1_8_15 250.00000000000003
R_1_8_14_2 Node1_8_14 Node1_9_14 250.00000000000003
R_1_8_14_3 Node1_8_14 GND 100.0
R_1_8_15_1 Node1_8_15 Node1_8_16 250.00000000000003
R_1_8_15_2 Node1_8_15 Node1_9_15 250.00000000000003
R_1_8_15_3 Node1_8_15 GND 100.0
R_1_8_16_1 Node1_8_16 Node1_8_17 250.00000000000003
R_1_8_16_2 Node1_8_16 Node1_9_16 250.00000000000003
R_1_8_16_3 Node1_8_16 GND 100.0
R_1_8_17_1 Node1_8_17 Node1_8_18 250.00000000000003
R_1_8_17_2 Node1_8_17 Node1_9_17 250.00000000000003
R_1_8_17_3 Node1_8_17 GND 100.0
R_1_8_18_1 Node1_8_18 Node1_8_19 250.00000000000003
R_1_8_18_2 Node1_8_18 Node1_9_18 250.00000000000003
R_1_8_18_3 Node1_8_18 GND 100.0
R_1_8_19_2 Node1_8_19 Node1_9_19 250.00000000000003
R_1_8_19_3 Node1_8_19 GND 100.0
R_1_9_0_1 Node1_9_0 Node1_9_1 250.00000000000003
R_1_9_0_2 Node1_9_0 Node1_10_0 250.00000000000003
R_1_9_0_3 Node1_9_0 GND 100.0
R_1_9_1_1 Node1_9_1 Node1_9_2 250.00000000000003
R_1_9_1_2 Node1_9_1 Node1_10_1 250.00000000000003
R_1_9_1_3 Node1_9_1 GND 100.0
R_1_9_2_1 Node1_9_2 Node1_9_3 250.00000000000003
R_1_9_2_2 Node1_9_2 Node1_10_2 250.00000000000003
R_1_9_2_3 Node1_9_2 GND 100.0
R_1_9_3_1 Node1_9_3 Node1_9_4 250.00000000000003
R_1_9_3_2 Node1_9_3 Node1_10_3 250.00000000000003
R_1_9_3_3 Node1_9_3 GND 100.0
R_1_9_4_1 Node1_9_4 Node1_9_5 250.00000000000003
R_1_9_4_2 Node1_9_4 Node1_10_4 250.00000000000003
R_1_9_4_3 Node1_9_4 GND 100.0
R_1_9_5_1 Node1_9_5 Node1_9_6 250.00000000000003
R_1_9_5_2 Node1_9_5 Node1_10_5 250.00000000000003
R_1_9_5_3 Node1_9_5 GND 100.0
R_1_9_6_1 Node1_9_6 Node1_9_7 250.00000000000003
R_1_9_6_2 Node1_9_6 Node1_10_6 250.00000000000003
R_1_9_6_3 Node1_9_6 GND 100.0
R_1_9_7_1 Node1_9_7 Node1_9_8 250.00000000000003
R_1_9_7_2 Node1_9_7 Node1_10_7 250.00000000000003
R_1_9_7_3 Node1_9_7 GND 100.0
R_1_9_8_1 Node1_9_8 Node1_9_9 250.00000000000003
R_1_9_8_2 Node1_9_8 Node1_10_8 250.00000000000003
R_1_9_8_3 Node1_9_8 GND 100.0
R_1_9_9_1 Node1_9_9 Node1_9_10 250.00000000000003
R_1_9_9_2 Node1_9_9 Node1_10_9 250.00000000000003
R_1_9_9_3 Node1_9_9 GND 100.0
R_1_9_10_1 Node1_9_10 Node1_9_11 250.00000000000003
R_1_9_10_2 Node1_9_10 Node1_10_10 250.00000000000003
R_1_9_10_3 Node1_9_10 GND 100.0
R_1_9_11_1 Node1_9_11 Node1_9_12 250.00000000000003
R_1_9_11_2 Node1_9_11 Node1_10_11 250.00000000000003
R_1_9_11_3 Node1_9_11 GND 100.0
R_1_9_12_1 Node1_9_12 Node1_9_13 250.00000000000003
R_1_9_12_2 Node1_9_12 Node1_10_12 250.00000000000003
R_1_9_12_3 Node1_9_12 GND 100.0
R_1_9_13_1 Node1_9_13 Node1_9_14 250.00000000000003
R_1_9_13_2 Node1_9_13 Node1_10_13 250.00000000000003
R_1_9_13_3 Node1_9_13 GND 100.0
R_1_9_14_1 Node1_9_14 Node1_9_15 250.00000000000003
R_1_9_14_2 Node1_9_14 Node1_10_14 250.00000000000003
R_1_9_14_3 Node1_9_14 GND 100.0
R_1_9_15_1 Node1_9_15 Node1_9_16 250.00000000000003
R_1_9_15_2 Node1_9_15 Node1_10_15 250.00000000000003
R_1_9_15_3 Node1_9_15 GND 100.0
R_1_9_16_1 Node1_9_16 Node1_9_17 250.00000000000003
R_1_9_16_2 Node1_9_16 Node1_10_16 250.00000000000003
R_1_9_16_3 Node1_9_16 GND 100.0
R_1_9_17_1 Node1_9_17 Node1_9_18 250.00000000000003
R_1_9_17_2 Node1_9_17 Node1_10_17 250.00000000000003
R_1_9_17_3 Node1_9_17 GND 100.0
R_1_9_18_1 Node1_9_18 Node1_9_19 250.00000000000003
R_1_9_18_2 Node1_9_18 Node1_10_18 250.00000000000003
R_1_9_18_3 Node1_9_18 GND 100.0
R_1_9_19_2 Node1_9_19 Node1_10_19 250.00000000000003
R_1_9_19_3 Node1_9_19 GND 100.0
R_1_10_0_1 Node1_10_0 Node1_10_1 250.00000000000003
R_1_10_0_2 Node1_10_0 Node1_11_0 250.00000000000003
R_1_10_0_3 Node1_10_0 GND 100.0
R_1_10_1_1 Node1_10_1 Node1_10_2 250.00000000000003
R_1_10_1_2 Node1_10_1 Node1_11_1 250.00000000000003
R_1_10_1_3 Node1_10_1 GND 100.0
R_1_10_2_1 Node1_10_2 Node1_10_3 250.00000000000003
R_1_10_2_2 Node1_10_2 Node1_11_2 250.00000000000003
R_1_10_2_3 Node1_10_2 GND 100.0
R_1_10_3_1 Node1_10_3 Node1_10_4 250.00000000000003
R_1_10_3_2 Node1_10_3 Node1_11_3 250.00000000000003
R_1_10_3_3 Node1_10_3 GND 100.0
R_1_10_4_1 Node1_10_4 Node1_10_5 250.00000000000003
R_1_10_4_2 Node1_10_4 Node1_11_4 250.00000000000003
R_1_10_4_3 Node1_10_4 GND 100.0
R_1_10_5_1 Node1_10_5 Node1_10_6 250.00000000000003
R_1_10_5_2 Node1_10_5 Node1_11_5 250.00000000000003
R_1_10_5_3 Node1_10_5 GND 100.0
R_1_10_6_1 Node1_10_6 Node1_10_7 250.00000000000003
R_1_10_6_2 Node1_10_6 Node1_11_6 250.00000000000003
R_1_10_6_3 Node1_10_6 GND 100.0
R_1_10_7_1 Node1_10_7 Node1_10_8 250.00000000000003
R_1_10_7_2 Node1_10_7 Node1_11_7 250.00000000000003
R_1_10_7_3 Node1_10_7 GND 100.0
R_1_10_8_1 Node1_10_8 Node1_10_9 250.00000000000003
R_1_10_8_2 Node1_10_8 Node1_11_8 250.00000000000003
R_1_10_8_3 Node1_10_8 GND 100.0
R_1_10_9_1 Node1_10_9 Node1_10_10 250.00000000000003
R_1_10_9_2 Node1_10_9 Node1_11_9 250.00000000000003
R_1_10_9_3 Node1_10_9 GND 100.0
R_1_10_10_1 Node1_10_10 Node1_10_11 250.00000000000003
R_1_10_10_2 Node1_10_10 Node1_11_10 250.00000000000003
R_1_10_10_3 Node1_10_10 GND 100.0
R_1_10_11_1 Node1_10_11 Node1_10_12 250.00000000000003
R_1_10_11_2 Node1_10_11 Node1_11_11 250.00000000000003
R_1_10_11_3 Node1_10_11 GND 100.0
R_1_10_12_1 Node1_10_12 Node1_10_13 250.00000000000003
R_1_10_12_2 Node1_10_12 Node1_11_12 250.00000000000003
R_1_10_12_3 Node1_10_12 GND 100.0
R_1_10_13_1 Node1_10_13 Node1_10_14 250.00000000000003
R_1_10_13_2 Node1_10_13 Node1_11_13 250.00000000000003
R_1_10_13_3 Node1_10_13 GND 100.0
R_1_10_14_1 Node1_10_14 Node1_10_15 250.00000000000003
R_1_10_14_2 Node1_10_14 Node1_11_14 250.00000000000003
R_1_10_14_3 Node1_10_14 GND 100.0
R_1_10_15_1 Node1_10_15 Node1_10_16 250.00000000000003
R_1_10_15_2 Node1_10_15 Node1_11_15 250.00000000000003
R_1_10_15_3 Node1_10_15 GND 100.0
R_1_10_16_1 Node1_10_16 Node1_10_17 250.00000000000003
R_1_10_16_2 Node1_10_16 Node1_11_16 250.00000000000003
R_1_10_16_3 Node1_10_16 GND 100.0
R_1_10_17_1 Node1_10_17 Node1_10_18 250.00000000000003
R_1_10_17_2 Node1_10_17 Node1_11_17 250.00000000000003
R_1_10_17_3 Node1_10_17 GND 100.0
R_1_10_18_1 Node1_10_18 Node1_10_19 250.00000000000003
R_1_10_18_2 Node1_10_18 Node1_11_18 250.00000000000003
R_1_10_18_3 Node1_10_18 GND 100.0
R_1_10_19_2 Node1_10_19 Node1_11_19 250.00000000000003
R_1_10_19_3 Node1_10_19 GND 100.0
R_1_11_0_1 Node1_11_0 Node1_11_1 250.00000000000003
R_1_11_0_2 Node1_11_0 Node1_12_0 250.00000000000003
R_1_11_0_3 Node1_11_0 GND 100.0
R_1_11_1_1 Node1_11_1 Node1_11_2 250.00000000000003
R_1_11_1_2 Node1_11_1 Node1_12_1 250.00000000000003
R_1_11_1_3 Node1_11_1 GND 100.0
R_1_11_2_1 Node1_11_2 Node1_11_3 250.00000000000003
R_1_11_2_2 Node1_11_2 Node1_12_2 250.00000000000003
R_1_11_2_3 Node1_11_2 GND 100.0
R_1_11_3_1 Node1_11_3 Node1_11_4 250.00000000000003
R_1_11_3_2 Node1_11_3 Node1_12_3 250.00000000000003
R_1_11_3_3 Node1_11_3 GND 100.0
R_1_11_4_1 Node1_11_4 Node1_11_5 250.00000000000003
R_1_11_4_2 Node1_11_4 Node1_12_4 250.00000000000003
R_1_11_4_3 Node1_11_4 GND 100.0
R_1_11_5_1 Node1_11_5 Node1_11_6 250.00000000000003
R_1_11_5_2 Node1_11_5 Node1_12_5 250.00000000000003
R_1_11_5_3 Node1_11_5 GND 100.0
R_1_11_6_1 Node1_11_6 Node1_11_7 250.00000000000003
R_1_11_6_2 Node1_11_6 Node1_12_6 250.00000000000003
R_1_11_6_3 Node1_11_6 GND 100.0
R_1_11_7_1 Node1_11_7 Node1_11_8 250.00000000000003
R_1_11_7_2 Node1_11_7 Node1_12_7 250.00000000000003
R_1_11_7_3 Node1_11_7 GND 100.0
R_1_11_8_1 Node1_11_8 Node1_11_9 250.00000000000003
R_1_11_8_2 Node1_11_8 Node1_12_8 250.00000000000003
R_1_11_8_3 Node1_11_8 GND 100.0
R_1_11_9_1 Node1_11_9 Node1_11_10 250.00000000000003
R_1_11_9_2 Node1_11_9 Node1_12_9 250.00000000000003
R_1_11_9_3 Node1_11_9 GND 100.0
R_1_11_10_1 Node1_11_10 Node1_11_11 250.00000000000003
R_1_11_10_2 Node1_11_10 Node1_12_10 250.00000000000003
R_1_11_10_3 Node1_11_10 GND 100.0
R_1_11_11_1 Node1_11_11 Node1_11_12 250.00000000000003
R_1_11_11_2 Node1_11_11 Node1_12_11 250.00000000000003
R_1_11_11_3 Node1_11_11 GND 100.0
R_1_11_12_1 Node1_11_12 Node1_11_13 250.00000000000003
R_1_11_12_2 Node1_11_12 Node1_12_12 250.00000000000003
R_1_11_12_3 Node1_11_12 GND 100.0
R_1_11_13_1 Node1_11_13 Node1_11_14 250.00000000000003
R_1_11_13_2 Node1_11_13 Node1_12_13 250.00000000000003
R_1_11_13_3 Node1_11_13 GND 100.0
R_1_11_14_1 Node1_11_14 Node1_11_15 250.00000000000003
R_1_11_14_2 Node1_11_14 Node1_12_14 250.00000000000003
R_1_11_14_3 Node1_11_14 GND 100.0
R_1_11_15_1 Node1_11_15 Node1_11_16 250.00000000000003
R_1_11_15_2 Node1_11_15 Node1_12_15 250.00000000000003
R_1_11_15_3 Node1_11_15 GND 100.0
R_1_11_16_1 Node1_11_16 Node1_11_17 250.00000000000003
R_1_11_16_2 Node1_11_16 Node1_12_16 250.00000000000003
R_1_11_16_3 Node1_11_16 GND 100.0
R_1_11_17_1 Node1_11_17 Node1_11_18 250.00000000000003
R_1_11_17_2 Node1_11_17 Node1_12_17 250.00000000000003
R_1_11_17_3 Node1_11_17 GND 100.0
R_1_11_18_1 Node1_11_18 Node1_11_19 250.00000000000003
R_1_11_18_2 Node1_11_18 Node1_12_18 250.00000000000003
R_1_11_18_3 Node1_11_18 GND 100.0
R_1_11_19_2 Node1_11_19 Node1_12_19 250.00000000000003
R_1_11_19_3 Node1_11_19 GND 100.0
R_1_12_0_1 Node1_12_0 Node1_12_1 250.00000000000003
R_1_12_0_2 Node1_12_0 Node1_13_0 250.00000000000003
R_1_12_0_3 Node1_12_0 GND 100.0
R_1_12_1_1 Node1_12_1 Node1_12_2 250.00000000000003
R_1_12_1_2 Node1_12_1 Node1_13_1 250.00000000000003
R_1_12_1_3 Node1_12_1 GND 100.0
R_1_12_2_1 Node1_12_2 Node1_12_3 250.00000000000003
R_1_12_2_2 Node1_12_2 Node1_13_2 250.00000000000003
R_1_12_2_3 Node1_12_2 GND 100.0
R_1_12_3_1 Node1_12_3 Node1_12_4 250.00000000000003
R_1_12_3_2 Node1_12_3 Node1_13_3 250.00000000000003
R_1_12_3_3 Node1_12_3 GND 100.0
R_1_12_4_1 Node1_12_4 Node1_12_5 250.00000000000003
R_1_12_4_2 Node1_12_4 Node1_13_4 250.00000000000003
R_1_12_4_3 Node1_12_4 GND 100.0
R_1_12_5_1 Node1_12_5 Node1_12_6 250.00000000000003
R_1_12_5_2 Node1_12_5 Node1_13_5 250.00000000000003
R_1_12_5_3 Node1_12_5 GND 100.0
R_1_12_6_1 Node1_12_6 Node1_12_7 250.00000000000003
R_1_12_6_2 Node1_12_6 Node1_13_6 250.00000000000003
R_1_12_6_3 Node1_12_6 GND 100.0
R_1_12_7_1 Node1_12_7 Node1_12_8 250.00000000000003
R_1_12_7_2 Node1_12_7 Node1_13_7 250.00000000000003
R_1_12_7_3 Node1_12_7 GND 100.0
R_1_12_8_1 Node1_12_8 Node1_12_9 250.00000000000003
R_1_12_8_2 Node1_12_8 Node1_13_8 250.00000000000003
R_1_12_8_3 Node1_12_8 GND 100.0
R_1_12_9_1 Node1_12_9 Node1_12_10 250.00000000000003
R_1_12_9_2 Node1_12_9 Node1_13_9 250.00000000000003
R_1_12_9_3 Node1_12_9 GND 100.0
R_1_12_10_1 Node1_12_10 Node1_12_11 250.00000000000003
R_1_12_10_2 Node1_12_10 Node1_13_10 250.00000000000003
R_1_12_10_3 Node1_12_10 GND 100.0
R_1_12_11_1 Node1_12_11 Node1_12_12 250.00000000000003
R_1_12_11_2 Node1_12_11 Node1_13_11 250.00000000000003
R_1_12_11_3 Node1_12_11 GND 100.0
R_1_12_12_1 Node1_12_12 Node1_12_13 250.00000000000003
R_1_12_12_2 Node1_12_12 Node1_13_12 250.00000000000003
R_1_12_12_3 Node1_12_12 GND 100.0
R_1_12_13_1 Node1_12_13 Node1_12_14 250.00000000000003
R_1_12_13_2 Node1_12_13 Node1_13_13 250.00000000000003
R_1_12_13_3 Node1_12_13 GND 100.0
R_1_12_14_1 Node1_12_14 Node1_12_15 250.00000000000003
R_1_12_14_2 Node1_12_14 Node1_13_14 250.00000000000003
R_1_12_14_3 Node1_12_14 GND 100.0
R_1_12_15_1 Node1_12_15 Node1_12_16 250.00000000000003
R_1_12_15_2 Node1_12_15 Node1_13_15 250.00000000000003
R_1_12_15_3 Node1_12_15 GND 100.0
R_1_12_16_1 Node1_12_16 Node1_12_17 250.00000000000003
R_1_12_16_2 Node1_12_16 Node1_13_16 250.00000000000003
R_1_12_16_3 Node1_12_16 GND 100.0
R_1_12_17_1 Node1_12_17 Node1_12_18 250.00000000000003
R_1_12_17_2 Node1_12_17 Node1_13_17 250.00000000000003
R_1_12_17_3 Node1_12_17 GND 100.0
R_1_12_18_1 Node1_12_18 Node1_12_19 250.00000000000003
R_1_12_18_2 Node1_12_18 Node1_13_18 250.00000000000003
R_1_12_18_3 Node1_12_18 GND 100.0
R_1_12_19_2 Node1_12_19 Node1_13_19 250.00000000000003
R_1_12_19_3 Node1_12_19 GND 100.0
R_1_13_0_1 Node1_13_0 Node1_13_1 250.00000000000003
R_1_13_0_2 Node1_13_0 Node1_14_0 250.00000000000003
R_1_13_0_3 Node1_13_0 GND 100.0
R_1_13_1_1 Node1_13_1 Node1_13_2 250.00000000000003
R_1_13_1_2 Node1_13_1 Node1_14_1 250.00000000000003
R_1_13_1_3 Node1_13_1 GND 100.0
R_1_13_2_1 Node1_13_2 Node1_13_3 250.00000000000003
R_1_13_2_2 Node1_13_2 Node1_14_2 250.00000000000003
R_1_13_2_3 Node1_13_2 GND 100.0
R_1_13_3_1 Node1_13_3 Node1_13_4 250.00000000000003
R_1_13_3_2 Node1_13_3 Node1_14_3 250.00000000000003
R_1_13_3_3 Node1_13_3 GND 100.0
R_1_13_4_1 Node1_13_4 Node1_13_5 250.00000000000003
R_1_13_4_2 Node1_13_4 Node1_14_4 250.00000000000003
R_1_13_4_3 Node1_13_4 GND 100.0
R_1_13_5_1 Node1_13_5 Node1_13_6 250.00000000000003
R_1_13_5_2 Node1_13_5 Node1_14_5 250.00000000000003
R_1_13_5_3 Node1_13_5 GND 100.0
R_1_13_6_1 Node1_13_6 Node1_13_7 250.00000000000003
R_1_13_6_2 Node1_13_6 Node1_14_6 250.00000000000003
R_1_13_6_3 Node1_13_6 GND 100.0
R_1_13_7_1 Node1_13_7 Node1_13_8 250.00000000000003
R_1_13_7_2 Node1_13_7 Node1_14_7 250.00000000000003
R_1_13_7_3 Node1_13_7 GND 100.0
R_1_13_8_1 Node1_13_8 Node1_13_9 250.00000000000003
R_1_13_8_2 Node1_13_8 Node1_14_8 250.00000000000003
R_1_13_8_3 Node1_13_8 GND 100.0
R_1_13_9_1 Node1_13_9 Node1_13_10 250.00000000000003
R_1_13_9_2 Node1_13_9 Node1_14_9 250.00000000000003
R_1_13_9_3 Node1_13_9 GND 100.0
R_1_13_10_1 Node1_13_10 Node1_13_11 250.00000000000003
R_1_13_10_2 Node1_13_10 Node1_14_10 250.00000000000003
R_1_13_10_3 Node1_13_10 GND 100.0
R_1_13_11_1 Node1_13_11 Node1_13_12 250.00000000000003
R_1_13_11_2 Node1_13_11 Node1_14_11 250.00000000000003
R_1_13_11_3 Node1_13_11 GND 100.0
R_1_13_12_1 Node1_13_12 Node1_13_13 250.00000000000003
R_1_13_12_2 Node1_13_12 Node1_14_12 250.00000000000003
R_1_13_12_3 Node1_13_12 GND 100.0
R_1_13_13_1 Node1_13_13 Node1_13_14 250.00000000000003
R_1_13_13_2 Node1_13_13 Node1_14_13 250.00000000000003
R_1_13_13_3 Node1_13_13 GND 100.0
R_1_13_14_1 Node1_13_14 Node1_13_15 250.00000000000003
R_1_13_14_2 Node1_13_14 Node1_14_14 250.00000000000003
R_1_13_14_3 Node1_13_14 GND 100.0
R_1_13_15_1 Node1_13_15 Node1_13_16 250.00000000000003
R_1_13_15_2 Node1_13_15 Node1_14_15 250.00000000000003
R_1_13_15_3 Node1_13_15 GND 100.0
R_1_13_16_1 Node1_13_16 Node1_13_17 250.00000000000003
R_1_13_16_2 Node1_13_16 Node1_14_16 250.00000000000003
R_1_13_16_3 Node1_13_16 GND 100.0
R_1_13_17_1 Node1_13_17 Node1_13_18 250.00000000000003
R_1_13_17_2 Node1_13_17 Node1_14_17 250.00000000000003
R_1_13_17_3 Node1_13_17 GND 100.0
R_1_13_18_1 Node1_13_18 Node1_13_19 250.00000000000003
R_1_13_18_2 Node1_13_18 Node1_14_18 250.00000000000003
R_1_13_18_3 Node1_13_18 GND 100.0
R_1_13_19_2 Node1_13_19 Node1_14_19 250.00000000000003
R_1_13_19_3 Node1_13_19 GND 100.0
R_1_14_0_1 Node1_14_0 Node1_14_1 250.00000000000003
R_1_14_0_2 Node1_14_0 Node1_15_0 250.00000000000003
R_1_14_0_3 Node1_14_0 GND 100.0
R_1_14_1_1 Node1_14_1 Node1_14_2 250.00000000000003
R_1_14_1_2 Node1_14_1 Node1_15_1 250.00000000000003
R_1_14_1_3 Node1_14_1 GND 100.0
R_1_14_2_1 Node1_14_2 Node1_14_3 250.00000000000003
R_1_14_2_2 Node1_14_2 Node1_15_2 250.00000000000003
R_1_14_2_3 Node1_14_2 GND 100.0
R_1_14_3_1 Node1_14_3 Node1_14_4 250.00000000000003
R_1_14_3_2 Node1_14_3 Node1_15_3 250.00000000000003
R_1_14_3_3 Node1_14_3 GND 100.0
R_1_14_4_1 Node1_14_4 Node1_14_5 250.00000000000003
R_1_14_4_2 Node1_14_4 Node1_15_4 250.00000000000003
R_1_14_4_3 Node1_14_4 GND 100.0
R_1_14_5_1 Node1_14_5 Node1_14_6 250.00000000000003
R_1_14_5_2 Node1_14_5 Node1_15_5 250.00000000000003
R_1_14_5_3 Node1_14_5 GND 100.0
R_1_14_6_1 Node1_14_6 Node1_14_7 250.00000000000003
R_1_14_6_2 Node1_14_6 Node1_15_6 250.00000000000003
R_1_14_6_3 Node1_14_6 GND 100.0
R_1_14_7_1 Node1_14_7 Node1_14_8 250.00000000000003
R_1_14_7_2 Node1_14_7 Node1_15_7 250.00000000000003
R_1_14_7_3 Node1_14_7 GND 100.0
R_1_14_8_1 Node1_14_8 Node1_14_9 250.00000000000003
R_1_14_8_2 Node1_14_8 Node1_15_8 250.00000000000003
R_1_14_8_3 Node1_14_8 GND 100.0
R_1_14_9_1 Node1_14_9 Node1_14_10 250.00000000000003
R_1_14_9_2 Node1_14_9 Node1_15_9 250.00000000000003
R_1_14_9_3 Node1_14_9 GND 100.0
R_1_14_10_1 Node1_14_10 Node1_14_11 250.00000000000003
R_1_14_10_2 Node1_14_10 Node1_15_10 250.00000000000003
R_1_14_10_3 Node1_14_10 GND 100.0
R_1_14_11_1 Node1_14_11 Node1_14_12 250.00000000000003
R_1_14_11_2 Node1_14_11 Node1_15_11 250.00000000000003
R_1_14_11_3 Node1_14_11 GND 100.0
R_1_14_12_1 Node1_14_12 Node1_14_13 250.00000000000003
R_1_14_12_2 Node1_14_12 Node1_15_12 250.00000000000003
R_1_14_12_3 Node1_14_12 GND 100.0
R_1_14_13_1 Node1_14_13 Node1_14_14 250.00000000000003
R_1_14_13_2 Node1_14_13 Node1_15_13 250.00000000000003
R_1_14_13_3 Node1_14_13 GND 100.0
R_1_14_14_1 Node1_14_14 Node1_14_15 250.00000000000003
R_1_14_14_2 Node1_14_14 Node1_15_14 250.00000000000003
R_1_14_14_3 Node1_14_14 GND 100.0
R_1_14_15_1 Node1_14_15 Node1_14_16 250.00000000000003
R_1_14_15_2 Node1_14_15 Node1_15_15 250.00000000000003
R_1_14_15_3 Node1_14_15 GND 100.0
R_1_14_16_1 Node1_14_16 Node1_14_17 250.00000000000003
R_1_14_16_2 Node1_14_16 Node1_15_16 250.00000000000003
R_1_14_16_3 Node1_14_16 GND 100.0
R_1_14_17_1 Node1_14_17 Node1_14_18 250.00000000000003
R_1_14_17_2 Node1_14_17 Node1_15_17 250.00000000000003
R_1_14_17_3 Node1_14_17 GND 100.0
R_1_14_18_1 Node1_14_18 Node1_14_19 250.00000000000003
R_1_14_18_2 Node1_14_18 Node1_15_18 250.00000000000003
R_1_14_18_3 Node1_14_18 GND 100.0
R_1_14_19_2 Node1_14_19 Node1_15_19 250.00000000000003
R_1_14_19_3 Node1_14_19 GND 100.0
R_1_15_0_1 Node1_15_0 Node1_15_1 250.00000000000003
R_1_15_0_2 Node1_15_0 Node1_16_0 250.00000000000003
R_1_15_0_3 Node1_15_0 GND 100.0
R_1_15_1_1 Node1_15_1 Node1_15_2 250.00000000000003
R_1_15_1_2 Node1_15_1 Node1_16_1 250.00000000000003
R_1_15_1_3 Node1_15_1 GND 100.0
R_1_15_2_1 Node1_15_2 Node1_15_3 250.00000000000003
R_1_15_2_2 Node1_15_2 Node1_16_2 250.00000000000003
R_1_15_2_3 Node1_15_2 GND 100.0
R_1_15_3_1 Node1_15_3 Node1_15_4 250.00000000000003
R_1_15_3_2 Node1_15_3 Node1_16_3 250.00000000000003
R_1_15_3_3 Node1_15_3 GND 100.0
R_1_15_4_1 Node1_15_4 Node1_15_5 250.00000000000003
R_1_15_4_2 Node1_15_4 Node1_16_4 250.00000000000003
R_1_15_4_3 Node1_15_4 GND 100.0
R_1_15_5_1 Node1_15_5 Node1_15_6 250.00000000000003
R_1_15_5_2 Node1_15_5 Node1_16_5 250.00000000000003
R_1_15_5_3 Node1_15_5 GND 100.0
R_1_15_6_1 Node1_15_6 Node1_15_7 250.00000000000003
R_1_15_6_2 Node1_15_6 Node1_16_6 250.00000000000003
R_1_15_6_3 Node1_15_6 GND 100.0
R_1_15_7_1 Node1_15_7 Node1_15_8 250.00000000000003
R_1_15_7_2 Node1_15_7 Node1_16_7 250.00000000000003
R_1_15_7_3 Node1_15_7 GND 100.0
R_1_15_8_1 Node1_15_8 Node1_15_9 250.00000000000003
R_1_15_8_2 Node1_15_8 Node1_16_8 250.00000000000003
R_1_15_8_3 Node1_15_8 GND 100.0
R_1_15_9_1 Node1_15_9 Node1_15_10 250.00000000000003
R_1_15_9_2 Node1_15_9 Node1_16_9 250.00000000000003
R_1_15_9_3 Node1_15_9 GND 100.0
R_1_15_10_1 Node1_15_10 Node1_15_11 250.00000000000003
R_1_15_10_2 Node1_15_10 Node1_16_10 250.00000000000003
R_1_15_10_3 Node1_15_10 GND 100.0
R_1_15_11_1 Node1_15_11 Node1_15_12 250.00000000000003
R_1_15_11_2 Node1_15_11 Node1_16_11 250.00000000000003
R_1_15_11_3 Node1_15_11 GND 100.0
R_1_15_12_1 Node1_15_12 Node1_15_13 250.00000000000003
R_1_15_12_2 Node1_15_12 Node1_16_12 250.00000000000003
R_1_15_12_3 Node1_15_12 GND 100.0
R_1_15_13_1 Node1_15_13 Node1_15_14 250.00000000000003
R_1_15_13_2 Node1_15_13 Node1_16_13 250.00000000000003
R_1_15_13_3 Node1_15_13 GND 100.0
R_1_15_14_1 Node1_15_14 Node1_15_15 250.00000000000003
R_1_15_14_2 Node1_15_14 Node1_16_14 250.00000000000003
R_1_15_14_3 Node1_15_14 GND 100.0
R_1_15_15_1 Node1_15_15 Node1_15_16 250.00000000000003
R_1_15_15_2 Node1_15_15 Node1_16_15 250.00000000000003
R_1_15_15_3 Node1_15_15 GND 100.0
R_1_15_16_1 Node1_15_16 Node1_15_17 250.00000000000003
R_1_15_16_2 Node1_15_16 Node1_16_16 250.00000000000003
R_1_15_16_3 Node1_15_16 GND 100.0
R_1_15_17_1 Node1_15_17 Node1_15_18 250.00000000000003
R_1_15_17_2 Node1_15_17 Node1_16_17 250.00000000000003
R_1_15_17_3 Node1_15_17 GND 100.0
R_1_15_18_1 Node1_15_18 Node1_15_19 250.00000000000003
R_1_15_18_2 Node1_15_18 Node1_16_18 250.00000000000003
R_1_15_18_3 Node1_15_18 GND 100.0
R_1_15_19_2 Node1_15_19 Node1_16_19 250.00000000000003
R_1_15_19_3 Node1_15_19 GND 100.0
R_1_16_0_1 Node1_16_0 Node1_16_1 250.00000000000003
R_1_16_0_2 Node1_16_0 Node1_17_0 250.00000000000003
R_1_16_0_3 Node1_16_0 GND 100.0
R_1_16_1_1 Node1_16_1 Node1_16_2 250.00000000000003
R_1_16_1_2 Node1_16_1 Node1_17_1 250.00000000000003
R_1_16_1_3 Node1_16_1 GND 100.0
R_1_16_2_1 Node1_16_2 Node1_16_3 250.00000000000003
R_1_16_2_2 Node1_16_2 Node1_17_2 250.00000000000003
R_1_16_2_3 Node1_16_2 GND 100.0
R_1_16_3_1 Node1_16_3 Node1_16_4 250.00000000000003
R_1_16_3_2 Node1_16_3 Node1_17_3 250.00000000000003
R_1_16_3_3 Node1_16_3 GND 100.0
R_1_16_4_1 Node1_16_4 Node1_16_5 250.00000000000003
R_1_16_4_2 Node1_16_4 Node1_17_4 250.00000000000003
R_1_16_4_3 Node1_16_4 GND 100.0
R_1_16_5_1 Node1_16_5 Node1_16_6 250.00000000000003
R_1_16_5_2 Node1_16_5 Node1_17_5 250.00000000000003
R_1_16_5_3 Node1_16_5 GND 100.0
R_1_16_6_1 Node1_16_6 Node1_16_7 250.00000000000003
R_1_16_6_2 Node1_16_6 Node1_17_6 250.00000000000003
R_1_16_6_3 Node1_16_6 GND 100.0
R_1_16_7_1 Node1_16_7 Node1_16_8 250.00000000000003
R_1_16_7_2 Node1_16_7 Node1_17_7 250.00000000000003
R_1_16_7_3 Node1_16_7 GND 100.0
R_1_16_8_1 Node1_16_8 Node1_16_9 250.00000000000003
R_1_16_8_2 Node1_16_8 Node1_17_8 250.00000000000003
R_1_16_8_3 Node1_16_8 GND 100.0
R_1_16_9_1 Node1_16_9 Node1_16_10 250.00000000000003
R_1_16_9_2 Node1_16_9 Node1_17_9 250.00000000000003
R_1_16_9_3 Node1_16_9 GND 100.0
R_1_16_10_1 Node1_16_10 Node1_16_11 250.00000000000003
R_1_16_10_2 Node1_16_10 Node1_17_10 250.00000000000003
R_1_16_10_3 Node1_16_10 GND 100.0
R_1_16_11_1 Node1_16_11 Node1_16_12 250.00000000000003
R_1_16_11_2 Node1_16_11 Node1_17_11 250.00000000000003
R_1_16_11_3 Node1_16_11 GND 100.0
R_1_16_12_1 Node1_16_12 Node1_16_13 250.00000000000003
R_1_16_12_2 Node1_16_12 Node1_17_12 250.00000000000003
R_1_16_12_3 Node1_16_12 GND 100.0
R_1_16_13_1 Node1_16_13 Node1_16_14 250.00000000000003
R_1_16_13_2 Node1_16_13 Node1_17_13 250.00000000000003
R_1_16_13_3 Node1_16_13 GND 100.0
R_1_16_14_1 Node1_16_14 Node1_16_15 250.00000000000003
R_1_16_14_2 Node1_16_14 Node1_17_14 250.00000000000003
R_1_16_14_3 Node1_16_14 GND 100.0
R_1_16_15_1 Node1_16_15 Node1_16_16 250.00000000000003
R_1_16_15_2 Node1_16_15 Node1_17_15 250.00000000000003
R_1_16_15_3 Node1_16_15 GND 100.0
R_1_16_16_1 Node1_16_16 Node1_16_17 250.00000000000003
R_1_16_16_2 Node1_16_16 Node1_17_16 250.00000000000003
R_1_16_16_3 Node1_16_16 GND 100.0
R_1_16_17_1 Node1_16_17 Node1_16_18 250.00000000000003
R_1_16_17_2 Node1_16_17 Node1_17_17 250.00000000000003
R_1_16_17_3 Node1_16_17 GND 100.0
R_1_16_18_1 Node1_16_18 Node1_16_19 250.00000000000003
R_1_16_18_2 Node1_16_18 Node1_17_18 250.00000000000003
R_1_16_18_3 Node1_16_18 GND 100.0
R_1_16_19_2 Node1_16_19 Node1_17_19 250.00000000000003
R_1_16_19_3 Node1_16_19 GND 100.0
R_1_17_0_1 Node1_17_0 Node1_17_1 250.00000000000003
R_1_17_0_2 Node1_17_0 Node1_18_0 250.00000000000003
R_1_17_0_3 Node1_17_0 GND 100.0
R_1_17_1_1 Node1_17_1 Node1_17_2 250.00000000000003
R_1_17_1_2 Node1_17_1 Node1_18_1 250.00000000000003
R_1_17_1_3 Node1_17_1 GND 100.0
R_1_17_2_1 Node1_17_2 Node1_17_3 250.00000000000003
R_1_17_2_2 Node1_17_2 Node1_18_2 250.00000000000003
R_1_17_2_3 Node1_17_2 GND 100.0
R_1_17_3_1 Node1_17_3 Node1_17_4 250.00000000000003
R_1_17_3_2 Node1_17_3 Node1_18_3 250.00000000000003
R_1_17_3_3 Node1_17_3 GND 100.0
R_1_17_4_1 Node1_17_4 Node1_17_5 250.00000000000003
R_1_17_4_2 Node1_17_4 Node1_18_4 250.00000000000003
R_1_17_4_3 Node1_17_4 GND 100.0
R_1_17_5_1 Node1_17_5 Node1_17_6 250.00000000000003
R_1_17_5_2 Node1_17_5 Node1_18_5 250.00000000000003
R_1_17_5_3 Node1_17_5 GND 100.0
R_1_17_6_1 Node1_17_6 Node1_17_7 250.00000000000003
R_1_17_6_2 Node1_17_6 Node1_18_6 250.00000000000003
R_1_17_6_3 Node1_17_6 GND 100.0
R_1_17_7_1 Node1_17_7 Node1_17_8 250.00000000000003
R_1_17_7_2 Node1_17_7 Node1_18_7 250.00000000000003
R_1_17_7_3 Node1_17_7 GND 100.0
R_1_17_8_1 Node1_17_8 Node1_17_9 250.00000000000003
R_1_17_8_2 Node1_17_8 Node1_18_8 250.00000000000003
R_1_17_8_3 Node1_17_8 GND 100.0
R_1_17_9_1 Node1_17_9 Node1_17_10 250.00000000000003
R_1_17_9_2 Node1_17_9 Node1_18_9 250.00000000000003
R_1_17_9_3 Node1_17_9 GND 100.0
R_1_17_10_1 Node1_17_10 Node1_17_11 250.00000000000003
R_1_17_10_2 Node1_17_10 Node1_18_10 250.00000000000003
R_1_17_10_3 Node1_17_10 GND 100.0
R_1_17_11_1 Node1_17_11 Node1_17_12 250.00000000000003
R_1_17_11_2 Node1_17_11 Node1_18_11 250.00000000000003
R_1_17_11_3 Node1_17_11 GND 100.0
R_1_17_12_1 Node1_17_12 Node1_17_13 250.00000000000003
R_1_17_12_2 Node1_17_12 Node1_18_12 250.00000000000003
R_1_17_12_3 Node1_17_12 GND 100.0
R_1_17_13_1 Node1_17_13 Node1_17_14 250.00000000000003
R_1_17_13_2 Node1_17_13 Node1_18_13 250.00000000000003
R_1_17_13_3 Node1_17_13 GND 100.0
R_1_17_14_1 Node1_17_14 Node1_17_15 250.00000000000003
R_1_17_14_2 Node1_17_14 Node1_18_14 250.00000000000003
R_1_17_14_3 Node1_17_14 GND 100.0
R_1_17_15_1 Node1_17_15 Node1_17_16 250.00000000000003
R_1_17_15_2 Node1_17_15 Node1_18_15 250.00000000000003
R_1_17_15_3 Node1_17_15 GND 100.0
R_1_17_16_1 Node1_17_16 Node1_17_17 250.00000000000003
R_1_17_16_2 Node1_17_16 Node1_18_16 250.00000000000003
R_1_17_16_3 Node1_17_16 GND 100.0
R_1_17_17_1 Node1_17_17 Node1_17_18 250.00000000000003
R_1_17_17_2 Node1_17_17 Node1_18_17 250.00000000000003
R_1_17_17_3 Node1_17_17 GND 100.0
R_1_17_18_1 Node1_17_18 Node1_17_19 250.00000000000003
R_1_17_18_2 Node1_17_18 Node1_18_18 250.00000000000003
R_1_17_18_3 Node1_17_18 GND 100.0
R_1_17_19_2 Node1_17_19 Node1_18_19 250.00000000000003
R_1_17_19_3 Node1_17_19 GND 100.0
R_1_18_0_1 Node1_18_0 Node1_18_1 250.00000000000003
R_1_18_0_2 Node1_18_0 Node1_19_0 250.00000000000003
R_1_18_0_3 Node1_18_0 GND 100.0
R_1_18_1_1 Node1_18_1 Node1_18_2 250.00000000000003
R_1_18_1_2 Node1_18_1 Node1_19_1 250.00000000000003
R_1_18_1_3 Node1_18_1 GND 100.0
R_1_18_2_1 Node1_18_2 Node1_18_3 250.00000000000003
R_1_18_2_2 Node1_18_2 Node1_19_2 250.00000000000003
R_1_18_2_3 Node1_18_2 GND 100.0
R_1_18_3_1 Node1_18_3 Node1_18_4 250.00000000000003
R_1_18_3_2 Node1_18_3 Node1_19_3 250.00000000000003
R_1_18_3_3 Node1_18_3 GND 100.0
R_1_18_4_1 Node1_18_4 Node1_18_5 250.00000000000003
R_1_18_4_2 Node1_18_4 Node1_19_4 250.00000000000003
R_1_18_4_3 Node1_18_4 GND 100.0
R_1_18_5_1 Node1_18_5 Node1_18_6 250.00000000000003
R_1_18_5_2 Node1_18_5 Node1_19_5 250.00000000000003
R_1_18_5_3 Node1_18_5 GND 100.0
R_1_18_6_1 Node1_18_6 Node1_18_7 250.00000000000003
R_1_18_6_2 Node1_18_6 Node1_19_6 250.00000000000003
R_1_18_6_3 Node1_18_6 GND 100.0
R_1_18_7_1 Node1_18_7 Node1_18_8 250.00000000000003
R_1_18_7_2 Node1_18_7 Node1_19_7 250.00000000000003
R_1_18_7_3 Node1_18_7 GND 100.0
R_1_18_8_1 Node1_18_8 Node1_18_9 250.00000000000003
R_1_18_8_2 Node1_18_8 Node1_19_8 250.00000000000003
R_1_18_8_3 Node1_18_8 GND 100.0
R_1_18_9_1 Node1_18_9 Node1_18_10 250.00000000000003
R_1_18_9_2 Node1_18_9 Node1_19_9 250.00000000000003
R_1_18_9_3 Node1_18_9 GND 100.0
R_1_18_10_1 Node1_18_10 Node1_18_11 250.00000000000003
R_1_18_10_2 Node1_18_10 Node1_19_10 250.00000000000003
R_1_18_10_3 Node1_18_10 GND 100.0
R_1_18_11_1 Node1_18_11 Node1_18_12 250.00000000000003
R_1_18_11_2 Node1_18_11 Node1_19_11 250.00000000000003
R_1_18_11_3 Node1_18_11 GND 100.0
R_1_18_12_1 Node1_18_12 Node1_18_13 250.00000000000003
R_1_18_12_2 Node1_18_12 Node1_19_12 250.00000000000003
R_1_18_12_3 Node1_18_12 GND 100.0
R_1_18_13_1 Node1_18_13 Node1_18_14 250.00000000000003
R_1_18_13_2 Node1_18_13 Node1_19_13 250.00000000000003
R_1_18_13_3 Node1_18_13 GND 100.0
R_1_18_14_1 Node1_18_14 Node1_18_15 250.00000000000003
R_1_18_14_2 Node1_18_14 Node1_19_14 250.00000000000003
R_1_18_14_3 Node1_18_14 GND 100.0
R_1_18_15_1 Node1_18_15 Node1_18_16 250.00000000000003
R_1_18_15_2 Node1_18_15 Node1_19_15 250.00000000000003
R_1_18_15_3 Node1_18_15 GND 100.0
R_1_18_16_1 Node1_18_16 Node1_18_17 250.00000000000003
R_1_18_16_2 Node1_18_16 Node1_19_16 250.00000000000003
R_1_18_16_3 Node1_18_16 GND 100.0
R_1_18_17_1 Node1_18_17 Node1_18_18 250.00000000000003
R_1_18_17_2 Node1_18_17 Node1_19_17 250.00000000000003
R_1_18_17_3 Node1_18_17 GND 100.0
R_1_18_18_1 Node1_18_18 Node1_18_19 250.00000000000003
R_1_18_18_2 Node1_18_18 Node1_19_18 250.00000000000003
R_1_18_18_3 Node1_18_18 GND 100.0
R_1_18_19_2 Node1_18_19 Node1_19_19 250.00000000000003
R_1_18_19_3 Node1_18_19 GND 100.0
R_1_19_0_1 Node1_19_0 Node1_19_1 250.00000000000003
R_1_19_0_3 Node1_19_0 GND 100.0
R_1_19_1_1 Node1_19_1 Node1_19_2 250.00000000000003
R_1_19_1_3 Node1_19_1 GND 100.0
R_1_19_2_1 Node1_19_2 Node1_19_3 250.00000000000003
R_1_19_2_3 Node1_19_2 GND 100.0
R_1_19_3_1 Node1_19_3 Node1_19_4 250.00000000000003
R_1_19_3_3 Node1_19_3 GND 100.0
R_1_19_4_1 Node1_19_4 Node1_19_5 250.00000000000003
R_1_19_4_3 Node1_19_4 GND 100.0
R_1_19_5_1 Node1_19_5 Node1_19_6 250.00000000000003
R_1_19_5_3 Node1_19_5 GND 100.0
R_1_19_6_1 Node1_19_6 Node1_19_7 250.00000000000003
R_1_19_6_3 Node1_19_6 GND 100.0
R_1_19_7_1 Node1_19_7 Node1_19_8 250.00000000000003
R_1_19_7_3 Node1_19_7 GND 100.0
R_1_19_8_1 Node1_19_8 Node1_19_9 250.00000000000003
R_1_19_8_3 Node1_19_8 GND 100.0
R_1_19_9_1 Node1_19_9 Node1_19_10 250.00000000000003
R_1_19_9_3 Node1_19_9 GND 100.0
R_1_19_10_1 Node1_19_10 Node1_19_11 250.00000000000003
R_1_19_10_3 Node1_19_10 GND 100.0
R_1_19_11_1 Node1_19_11 Node1_19_12 250.00000000000003
R_1_19_11_3 Node1_19_11 GND 100.0
R_1_19_12_1 Node1_19_12 Node1_19_13 250.00000000000003
R_1_19_12_3 Node1_19_12 GND 100.0
R_1_19_13_1 Node1_19_13 Node1_19_14 250.00000000000003
R_1_19_13_3 Node1_19_13 GND 100.0
R_1_19_14_1 Node1_19_14 Node1_19_15 250.00000000000003
R_1_19_14_3 Node1_19_14 GND 100.0
R_1_19_15_1 Node1_19_15 Node1_19_16 250.00000000000003
R_1_19_15_3 Node1_19_15 GND 100.0
R_1_19_16_1 Node1_19_16 Node1_19_17 250.00000000000003
R_1_19_16_3 Node1_19_16 GND 100.0
R_1_19_17_1 Node1_19_17 Node1_19_18 250.00000000000003
R_1_19_17_3 Node1_19_17 GND 100.0
R_1_19_18_1 Node1_19_18 Node1_19_19 250.00000000000003
R_1_19_18_3 Node1_19_18 GND 100.0
R_1_19_19_3 Node1_19_19 GND 100.0
.OP
.OPTIONS LINSOL TYPE=KLU
.PRINT DC FORMAT=CSV PRECISION=4 V(Node0_0_0) V(Node0_0_1) V(Node0_0_2) V(Node0_0_3) V(Node0_0_4) V(Node0_0_5) V(Node0_0_6) V(Node0_0_7) V(Node0_0_8) V(Node0_0_9) V(Node0_0_10) V(Node0_0_11) V(Node0_0_12) V(Node0_0_13) V(Node0_0_14) V(Node0_0_15) V(Node0_0_16) V(Node0_0_17) V(Node0_0_18) V(Node0_0_19) V(Node0_1_0) V(Node0_1_1) V(Node0_1_2) V(Node0_1_3) V(Node0_1_4) V(Node0_1_5) V(Node0_1_6) V(Node0_1_7) V(Node0_1_8) V(Node0_1_9) V(Node0_1_10) V(Node0_1_11) V(Node0_1_12) V(Node0_1_13) V(Node0_1_14) V(Node0_1_15) V(Node0_1_16) V(Node0_1_17) V(Node0_1_18) V(Node0_1_19) V(Node0_2_0) V(Node0_2_1) V(Node0_2_2) V(Node0_2_3) V(Node0_2_4) V(Node0_2_5) V(Node0_2_6) V(Node0_2_7) V(Node0_2_8) V(Node0_2_9) V(Node0_2_10) V(Node0_2_11) V(Node0_2_12) V(Node0_2_13) V(Node0_2_14) V(Node0_2_15) V(Node0_2_16) V(Node0_2_17) V(Node0_2_18) V(Node0_2_19) V(Node0_3_0) V(Node0_3_1) V(Node0_3_2) V(Node0_3_3) V(Node0_3_4) V(Node0_3_5) V(Node0_3_6) V(Node0_3_7) V(Node0_3_8) V(Node0_3_9) V(Node0_3_10) V(Node0_3_11) V(Node0_3_12) V(Node0_3_13) V(Node0_3_14) V(Node0_3_15) V(Node0_3_16) V(Node0_3_17) V(Node0_3_18) V(Node0_3_19) V(Node0_4_0) V(Node0_4_1) V(Node0_4_2) V(Node0_4_3) V(Node0_4_4) V(Node0_4_5) V(Node0_4_6) V(Node0_4_7) V(Node0_4_8) V(Node0_4_9) V(Node0_4_10) V(Node0_4_11) V(Node0_4_12) V(Node0_4_13) V(Node0_4_14) V(Node0_4_15) V(Node0_4_16) V(Node0_4_17) V(Node0_4_18) V(Node0_4_19) V(Node0_5_0) V(Node0_5_1) V(Node0_5_2) V(Node0_5_3) V(Node0_5_4) V(Node0_5_5) V(Node0_5_6) V(Node0_5_7) V(Node0_5_8) V(Node0_5_9) V(Node0_5_10) V(Node0_5_11) V(Node0_5_12) V(Node0_5_13) V(Node0_5_14) V(Node0_5_15) V(Node0_5_16) V(Node0_5_17) V(Node0_5_18) V(Node0_5_19) V(Node0_6_0) V(Node0_6_1) V(Node0_6_2) V(Node0_6_3) V(Node0_6_4) V(Node0_6_5) V(Node0_6_6) V(Node0_6_7) V(Node0_6_8) V(Node0_6_9) V(Node0_6_10) V(Node0_6_11) V(Node0_6_12) V(Node0_6_13) V(Node0_6_14) V(Node0_6_15) V(Node0_6_16) V(Node0_6_17) V(Node0_6_18) V(Node0_6_19) V(Node0_7_0) V(Node0_7_1) V(Node0_7_2) V(Node0_7_3) V(Node0_7_4) V(Node0_7_5) V(Node0_7_6) V(Node0_7_7) V(Node0_7_8) V(Node0_7_9) V(Node0_7_10) V(Node0_7_11) V(Node0_7_12) V(Node0_7_13) V(Node0_7_14) V(Node0_7_15) V(Node0_7_16) V(Node0_7_17) V(Node0_7_18) V(Node0_7_19) V(Node0_8_0) V(Node0_8_1) V(Node0_8_2) V(Node0_8_3) V(Node0_8_4) V(Node0_8_5) V(Node0_8_6) V(Node0_8_7) V(Node0_8_8) V(Node0_8_9) V(Node0_8_10) V(Node0_8_11) V(Node0_8_12) V(Node0_8_13) V(Node0_8_14) V(Node0_8_15) V(Node0_8_16) V(Node0_8_17) V(Node0_8_18) V(Node0_8_19) V(Node0_9_0) V(Node0_9_1) V(Node0_9_2) V(Node0_9_3) V(Node0_9_4) V(Node0_9_5) V(Node0_9_6) V(Node0_9_7) V(Node0_9_8) V(Node0_9_9) V(Node0_9_10) V(Node0_9_11) V(Node0_9_12) V(Node0_9_13) V(Node0_9_14) V(Node0_9_15) V(Node0_9_16) V(Node0_9_17) V(Node0_9_18) V(Node0_9_19) V(Node0_10_0) V(Node0_10_1) V(Node0_10_2) V(Node0_10_3) V(Node0_10_4) V(Node0_10_5) V(Node0_10_6) V(Node0_10_7) V(Node0_10_8) V(Node0_10_9) V(Node0_10_10) V(Node0_10_11) V(Node0_10_12) V(Node0_10_13) V(Node0_10_14) V(Node0_10_15) V(Node0_10_16) V(Node0_10_17) V(Node0_10_18) V(Node0_10_19) V(Node0_11_0) V(Node0_11_1) V(Node0_11_2) V(Node0_11_3) V(Node0_11_4) V(Node0_11_5) V(Node0_11_6) V(Node0_11_7) V(Node0_11_8) V(Node0_11_9) V(Node0_11_10) V(Node0_11_11) V(Node0_11_12) V(Node0_11_13) V(Node0_11_14) V(Node0_11_15) V(Node0_11_16) V(Node0_11_17) V(Node0_11_18) V(Node0_11_19) V(Node0_12_0) V(Node0_12_1) V(Node0_12_2) V(Node0_12_3) V(Node0_12_4) V(Node0_12_5) V(Node0_12_6) V(Node0_12_7) V(Node0_12_8) V(Node0_12_9) V(Node0_12_10) V(Node0_12_11) V(Node0_12_12) V(Node0_12_13) V(Node0_12_14) V(Node0_12_15) V(Node0_12_16) V(Node0_12_17) V(Node0_12_18) V(Node0_12_19) V(Node0_13_0) V(Node0_13_1) V(Node0_13_2) V(Node0_13_3) V(Node0_13_4) V(Node0_13_5) V(Node0_13_6) V(Node0_13_7) V(Node0_13_8) V(Node0_13_9) V(Node0_13_10) V(Node0_13_11) V(Node0_13_12) V(Node0_13_13) V(Node0_13_14) V(Node0_13_15) V(Node0_13_16) V(Node0_13_17) V(Node0_13_18) V(Node0_13_19) V(Node0_14_0) V(Node0_14_1) V(Node0_14_2) V(Node0_14_3) V(Node0_14_4) V(Node0_14_5) V(Node0_14_6) V(Node0_14_7) V(Node0_14_8) V(Node0_14_9) V(Node0_14_10) V(Node0_14_11) V(Node0_14_12) V(Node0_14_13) V(Node0_14_14) V(Node0_14_15) V(Node0_14_16) V(Node0_14_17) V(Node0_14_18) V(Node0_14_19) V(Node0_15_0) V(Node0_15_1) V(Node0_15_2) V(Node0_15_3) V(Node0_15_4) V(Node0_15_5) V(Node0_15_6) V(Node0_15_7) V(Node0_15_8) V(Node0_15_9) V(Node0_15_10) V(Node0_15_11) V(Node0_15_12) V(Node0_15_13) V(Node0_15_14) V(Node0_15_15) V(Node0_15_16) V(Node0_15_17) V(Node0_15_18) V(Node0_15_19) V(Node0_16_0) V(Node0_16_1) V(Node0_16_2) V(Node0_16_3) V(Node0_16_4) V(Node0_16_5) V(Node0_16_6) V(Node0_16_7) V(Node0_16_8) V(Node0_16_9) V(Node0_16_10) V(Node0_16_11) V(Node0_16_12) V(Node0_16_13) V(Node0_16_14) V(Node0_16_15) V(Node0_16_16) V(Node0_16_17) V(Node0_16_18) V(Node0_16_19) V(Node0_17_0) V(Node0_17_1) V(Node0_17_2) V(Node0_17_3) V(Node0_17_4) V(Node0_17_5) V(Node0_17_6) V(Node0_17_7) V(Node0_17_8) V(Node0_17_9) V(Node0_17_10) V(Node0_17_11) V(Node0_17_12) V(Node0_17_13) V(Node0_17_14) V(Node0_17_15) V(Node0_17_16) V(Node0_17_17) V(Node0_17_18) V(Node0_17_19) V(Node0_18_0) V(Node0_18_1) V(Node0_18_2) V(Node0_18_3) V(Node0_18_4) V(Node0_18_5) V(Node0_18_6) V(Node0_18_7) V(Node0_18_8) V(Node0_18_9) V(Node0_18_10) V(Node0_18_11) V(Node0_18_12) V(Node0_18_13) V(Node0_18_14) V(Node0_18_15) V(Node0_18_16) V(Node0_18_17) V(Node0_18_18) V(Node0_18_19) V(Node0_19_0) V(Node0_19_1) V(Node0_19_2) V(Node0_19_3) V(Node0_19_4) V(Node0_19_5) V(Node0_19_6) V(Node0_19_7) V(Node0_19_8) V(Node0_19_9) V(Node0_19_10) V(Node0_19_11) V(Node0_19_12) V(Node0_19_13) V(Node0_19_14) V(Node0_19_15) V(Node0_19_16) V(Node0_19_17) V(Node0_19_18) V(Node0_19_19) V(Node1_0_0) V(Node1_0_1) V(Node1_0_2) V(Node1_0_3) V(Node1_0_4) V(Node1_0_5) V(Node1_0_6) V(Node1_0_7) V(Node1_0_8) V(Node1_0_9) V(Node1_0_10) V(Node1_0_11) V(Node1_0_12) V(Node1_0_13) V(Node1_0_14) V(Node1_0_15) V(Node1_0_16) V(Node1_0_17) V(Node1_0_18) V(Node1_0_19) V(Node1_1_0) V(Node1_1_1) V(Node1_1_2) V(Node1_1_3) V(Node1_1_4) V(Node1_1_5) V(Node1_1_6) V(Node1_1_7) V(Node1_1_8) V(Node1_1_9) V(Node1_1_10) V(Node1_1_11) V(Node1_1_12) V(Node1_1_13) V(Node1_1_14) V(Node1_1_15) V(Node1_1_16) V(Node1_1_17) V(Node1_1_18) V(Node1_1_19) V(Node1_2_0) V(Node1_2_1) V(Node1_2_2) V(Node1_2_3) V(Node1_2_4) V(Node1_2_5) V(Node1_2_6) V(Node1_2_7) V(Node1_2_8) V(Node1_2_9) V(Node1_2_10) V(Node1_2_11) V(Node1_2_12) V(Node1_2_13) V(Node1_2_14) V(Node1_2_15) V(Node1_2_16) V(Node1_2_17) V(Node1_2_18) V(Node1_2_19) V(Node1_3_0) V(Node1_3_1) V(Node1_3_2) V(Node1_3_3) V(Node1_3_4) V(Node1_3_5) V(Node1_3_6) V(Node1_3_7) V(Node1_3_8) V(Node1_3_9) V(Node1_3_10) V(Node1_3_11) V(Node1_3_12) V(Node1_3_13) V(Node1_3_14) V(Node1_3_15) V(Node1_3_16) V(Node1_3_17) V(Node1_3_18) V(Node1_3_19) V(Node1_4_0) V(Node1_4_1) V(Node1_4_2) V(Node1_4_3) V(Node1_4_4) V(Node1_4_5) V(Node1_4_6) V(Node1_4_7) V(Node1_4_8) V(Node1_4_9) V(Node1_4_10) V(Node1_4_11) V(Node1_4_12) V(Node1_4_13) V(Node1_4_14) V(Node1_4_15) V(Node1_4_16) V(Node1_4_17) V(Node1_4_18) V(Node1_4_19) V(Node1_5_0) V(Node1_5_1) V(Node1_5_2) V(Node1_5_3) V(Node1_5_4) V(Node1_5_5) V(Node1_5_6) V(Node1_5_7) V(Node1_5_8) V(Node1_5_9) V(Node1_5_10) V(Node1_5_11) V(Node1_5_12) V(Node1_5_13) V(Node1_5_14) V(Node1_5_15) V(Node1_5_16) V(Node1_5_17) V(Node1_5_18) V(Node1_5_19) V(Node1_6_0) V(Node1_6_1) V(Node1_6_2) V(Node1_6_3) V(Node1_6_4) V(Node1_6_5) V(Node1_6_6) V(Node1_6_7) V(Node1_6_8) V(Node1_6_9) V(Node1_6_10) V(Node1_6_11) V(Node1_6_12) V(Node1_6_13) V(Node1_6_14) V(Node1_6_15) V(Node1_6_16) V(Node1_6_17) V(Node1_6_18) V(Node1_6_19) V(Node1_7_0) V(Node1_7_1) V(Node1_7_2) V(Node1_7_3) V(Node1_7_4) V(Node1_7_5) V(Node1_7_6) V(Node1_7_7) V(Node1_7_8) V(Node1_7_9) V(Node1_7_10) V(Node1_7_11) V(Node1_7_12) V(Node1_7_13) V(Node1_7_14) V(Node1_7_15) V(Node1_7_16) V(Node1_7_17) V(Node1_7_18) V(Node1_7_19) V(Node1_8_0) V(Node1_8_1) V(Node1_8_2) V(Node1_8_3) V(Node1_8_4) V(Node1_8_5) V(Node1_8_6) V(Node1_8_7) V(Node1_8_8) V(Node1_8_9) V(Node1_8_10) V(Node1_8_11) V(Node1_8_12) V(Node1_8_13) V(Node1_8_14) V(Node1_8_15) V(Node1_8_16) V(Node1_8_17) V(Node1_8_18) V(Node1_8_19) V(Node1_9_0) V(Node1_9_1) V(Node1_9_2) V(Node1_9_3) V(Node1_9_4) V(Node1_9_5) V(Node1_9_6) V(Node1_9_7) V(Node1_9_8) V(Node1_9_9) V(Node1_9_10) V(Node1_9_11) V(Node1_9_12) V(Node1_9_13) V(Node1_9_14) V(Node1_9_15) V(Node1_9_16) V(Node1_9_17) V(Node1_9_18) V(Node1_9_19) V(Node1_10_0) V(Node1_10_1) V(Node1_10_2) V(Node1_10_3) V(Node1_10_4) V(Node1_10_5) V(Node1_10_6) V(Node1_10_7) V(Node1_10_8) V(Node1_10_9) V(Node1_10_10) V(Node1_10_11) V(Node1_10_12) V(Node1_10_13) V(Node1_10_14) V(Node1_10_15) V(Node1_10_16) V(Node1_10_17) V(Node1_10_18) V(Node1_10_19) V(Node1_11_0) V(Node1_11_1) V(Node1_11_2) V(Node1_11_3) V(Node1_11_4) V(Node1_11_5) V(Node1_11_6) V(Node1_11_7) V(Node1_11_8) V(Node1_11_9) V(Node1_11_10) V(Node1_11_11) V(Node1_11_12) V(Node1_11_13) V(Node1_11_14) V(Node1_11_15) V(Node1_11_16) V(Node1_11_17) V(Node1_11_18) V(Node1_11_19) V(Node1_12_0) V(Node1_12_1) V(Node1_12_2) V(Node1_12_3) V(Node1_12_4) V(Node1_12_5) V(Node1_12_6) V(Node1_12_7) V(Node1_12_8) V(Node1_12_9) V(Node1_12_10) V(Node1_12_11) V(Node1_12_12) V(Node1_12_13) V(Node1_12_14) V(Node1_12_15) V(Node1_12_16) V(Node1_12_17) V(Node1_12_18) V(Node1_12_19) V(Node1_13_0) V(Node1_13_1) V(Node1_13_2) V(Node1_13_3) V(Node1_13_4) V(Node1_13_5) V(Node1_13_6) V(Node1_13_7) V(Node1_13_8) V(Node1_13_9) V(Node1_13_10) V(Node1_13_11) V(Node1_13_12) V(Node1_13_13) V(Node1_13_14) V(Node1_13_15) V(Node1_13_16) V(Node1_13_17) V(Node1_13_18) V(Node1_13_19) V(Node1_14_0) V(Node1_14_1) V(Node1_14_2) V(Node1_14_3) V(Node1_14_4) V(Node1_14_5) V(Node1_14_6) V(Node1_14_7) V(Node1_14_8) V(Node1_14_9) V(Node1_14_10) V(Node1_14_11) V(Node1_14_12) V(Node1_14_13) V(Node1_14_14) V(Node1_14_15) V(Node1_14_16) V(Node1_14_17) V(Node1_14_18) V(Node1_14_19) V(Node1_15_0) V(Node1_15_1) V(Node1_15_2) V(Node1_15_3) V(Node1_15_4) V(Node1_15_5) V(Node1_15_6) V(Node1_15_7) V(Node1_15_8) V(Node1_15_9) V(Node1_15_10) V(Node1_15_11) V(Node1_15_12) V(Node1_15_13) V(Node1_15_14) V(Node1_15_15) V(Node1_15_16) V(Node1_15_17) V(Node1_15_18) V(Node1_15_19) V(Node1_16_0) V(Node1_16_1) V(Node1_16_2) V(Node1_16_3) V(Node1_16_4) V(Node1_16_5) V(Node1_16_6) V(Node1_16_7) V(Node1_16_8) V(Node1_16_9) V(Node1_16_10) V(Node1_16_11) V(Node1_16_12) V(Node1_16_13) V(Node1_16_14) V(Node1_16_15) V(Node1_16_16) V(Node1_16_17) V(Node1_16_18) V(Node1_16_19) V(Node1_17_0) V(Node1_17_1) V(Node1_17_2) V(Node1_17_3) V(Node1_17_4) V(Node1_17_5) V(Node1_17_6) V(Node1_17_7) V(Node1_17_8) V(Node1_17_9) V(Node1_17_10) V(Node1_17_11) V(Node1_17_12) V(Node1_17_13) V(Node1_17_14) V(Node1_17_15) V(Node1_17_16) V(Node1_17_17) V(Node1_17_18) V(Node1_17_19) V(Node1_18_0) V(Node1_18_1) V(Node1_18_2) V(Node1_18_3) V(Node1_18_4) V(Node1_18_5) V(Node1_18_6) V(Node1_18_7) V(Node1_18_8) V(Node1_18_9) V(Node1_18_10) V(Node1_18_11) V(Node1_18_12) V(Node1_18_13) V(Node1_18_14) V(Node1_18_15) V(Node1_18_16) V(Node1_18_17) V(Node1_18_18) V(Node1_18_19) V(Node1_19_0) V(Node1_19_1) V(Node1_19_2) V(Node1_19_3) V(Node1_19_4) V(Node1_19_5) V(Node1_19_6) V(Node1_19_7) V(Node1_19_8) V(Node1_19_9) V(Node1_19_10) V(Node1_19_11) V(Node1_19_12) V(Node1_19_13) V(Node1_19_14) V(Node1_19_15) V(Node1_19_16) V(Node1_19_17) V(Node1_19_18) V(Node1_19_19)
.SAVE TYPE=IC
.end
